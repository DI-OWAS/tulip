* NGSPICE file created from sg13g2_xor2_1_flat.ext - technology: ihp-sg13g2

.subckt sg13g2_xor2_1_flat X VDD B A VSS
X0 VSS a_209_168# X VSS sg13_lv_nmos ad=0.3108p pd=2.32u as=0.1628p ps=1.18u w=0.74u l=0.13u
X1 VDD A a_380_412# VDD sg13_lv_pmos ad=0.2128p pd=1.5u as=0.3808p ps=2.92u w=1.12u l=0.13u
X2 a_380_412# B VDD VDD sg13_lv_pmos ad=0.2128p pd=1.5u as=0.2128p ps=1.5u w=1.12u l=0.13u
X3 X a_209_168# a_380_412# VDD sg13_lv_pmos ad=0.3808p pd=2.92u as=0.2128p ps=1.5u w=1.12u l=0.13u
X4 a_177_436# A VDD VDD sg13_lv_pmos ad=0.1225p pd=1.245u as=0.36p ps=2.72u w=1u l=0.13u
X5 a_209_168# A VSS VSS sg13_lv_nmos ad=0.17462p pd=1.185u as=0.374p ps=2.46u w=0.55u l=0.13u
X6 a_209_168# B a_177_436# VDD sg13_lv_pmos ad=0.34p pd=2.68u as=0.1225p ps=1.245u w=1u l=0.13u
X7 VSS B a_209_168# VSS sg13_lv_nmos ad=0.15245p pd=1.17u as=0.17462p ps=1.185u w=0.55u l=0.13u
X8 a_474_130# A VSS VSS sg13_lv_nmos ad=88.8f pd=0.98u as=0.15245p ps=1.17u w=0.74u l=0.13u
X9 X B a_474_130# VSS sg13_lv_nmos ad=0.1628p pd=1.18u as=88.8f ps=0.98u w=0.74u l=0.13u
C0 B VDD 0.14503f
C1 A a_380_412# 0.01011f
C2 B a_209_168# 0.37832f
C3 B a_380_412# 0.01144f
C4 VDD a_209_168# 0.25368f
C5 a_177_436# a_209_168# 0.0104f
C6 VDD a_380_412# 0.20834f
C7 a_209_168# a_380_412# 0.36535f
C8 B X 0.02441f
C9 B A 0.14298f
C10 VDD X 0.04071f
C11 X a_209_168# 0.2305f
C12 VDD A 0.19819f
C13 A a_209_168# 0.11136f
C14 X a_380_412# 0.09715f
C15 X VSS 0.2512f
C16 B VSS 0.52522f
C17 A VSS 0.77274f
C18 VDD VSS 0.19794f
C19 a_209_168# VSS 0.38299f $ **FLOATING
.ends
