* NGSPICE file created from sg13g2_tiehi_flat.ext - technology: ihp-sg13g2

.subckt sg13g2_tiehi_flat L_HI VDD VSS
X0 L_HI a_222_366# a_23_615# VDD sg13_lv_pmos ad=0.3927p pd=2.99u as=0.4657p ps=2.54u w=1.155u l=0.13u
X1 a_23_615# a_23_195# a_23_429# VDD sg13_lv_pmos ad=0.4657p pd=2.54u as=0.2442p ps=2.06u w=0.66u l=0.13u
X2 a_222_366# a_23_429# a_117_195# VSS sg13_lv_nmos ad=0.27427p pd=2.28u as=0.2307p ps=1.615u w=0.795u l=0.13u
X3 a_117_195# a_23_195# a_23_195# VSS sg13_lv_nmos ad=0.2307p pd=1.615u as=0.102p ps=1.28u w=0.3u l=0.13u
C0 VDD a_23_429# 0.05316f
C1 a_23_615# a_23_429# 0.01952f
C2 VDD a_222_366# 0.0819f
C3 VDD L_HI 0.02976f
C4 VDD a_23_195# 0.06189f
C5 a_222_366# a_23_429# 0.14868f
C6 L_HI a_23_429# 0.01337f
C7 a_23_195# a_23_429# 0.10864f
C8 a_222_366# L_HI 0.06927f
C9 a_23_195# a_222_366# 0.0229f
C10 VDD a_23_615# 0.02259f
C11 L_HI VSS 0.03254f
C12 VDD VSS 0.09304f
C13 a_117_195# VSS 0.01105f $ **FLOATING
C14 a_23_429# VSS 0.21051f $ **FLOATING
C15 a_23_195# VSS 0.2301f $ **FLOATING
C16 a_222_366# VSS 0.20576f $ **FLOATING
.ends
