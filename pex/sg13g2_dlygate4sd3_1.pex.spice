* NGSPICE file created from sg13g2_dlygate4sd3_1_flat.ext - technology: ihp-sg13g2

.subckt sg13g2_dlygate4sd3_1_flat A VDD VSS X
X0 VDD A a_56_118# VDD sg13_lv_pmos ad=0.1523p pd=1.38u as=0.1428p ps=1.52u w=0.42u l=0.13u
X1 VSS a_326_118# a_438_182# VSS sg13_lv_nmos ad=0.1426p pd=1.16u as=0.1428p ps=1.52u w=0.42u l=0.5u
X2 VDD a_326_118# a_438_182# VDD sg13_lv_pmos ad=0.2254p pd=1.53u as=0.34p ps=2.68u w=1u l=0.5u
X3 X a_438_182# VDD VDD sg13_lv_pmos ad=0.4256p pd=3u as=0.2254p ps=1.53u w=1.12u l=0.13u
X4 a_326_118# a_56_118# VDD VDD sg13_lv_pmos ad=0.34p pd=2.68u as=0.1523p ps=1.38u w=1u l=0.5u
X5 VSS A a_56_118# VSS sg13_lv_nmos ad=79.8f pd=0.8u as=0.1428p ps=1.52u w=0.42u l=0.13u
X6 X a_438_182# VSS VSS sg13_lv_nmos ad=0.2516p pd=2.16u as=0.1426p ps=1.16u w=0.74u l=0.13u
X7 a_326_118# a_56_118# VSS VSS sg13_lv_nmos ad=0.1428p pd=1.52u as=79.8f ps=0.8u w=0.42u l=0.5u
C0 A VDD 0.09104f
C1 VDD a_438_182# 0.18056f
C2 A a_56_118# 0.38085f
C3 VDD a_56_118# 0.30057f
C4 VDD X 0.15427f
C5 a_326_118# VDD 0.21648f
C6 X a_438_182# 0.15044f
C7 a_326_118# a_438_182# 0.45404f
C8 a_326_118# a_56_118# 0.25305f
C9 X VSS 0.18594f
C10 A VSS 0.22317f
C11 VDD VSS 0.17259f
C12 a_438_182# VSS 0.37543f $ **FLOATING
C13 a_326_118# VSS 0.31697f $ **FLOATING
C14 a_56_118# VSS 0.48098f $ **FLOATING
.ends
