* NGSPICE file created from sg13g2_xnor2_1_flat.ext - technology: ihp-sg13g2

.subckt sg13g2_xnor2_1_flat Y B VDD A VSS
X0 a_192_429# A VDD VDD sg13_lv_pmos ad=0.1596p pd=1.22u as=0.4536p ps=2.76u w=0.84u l=0.13u
X1 VSS A a_341_118# VSS sg13_lv_nmos ad=0.1898p pd=1.36u as=0.2516p ps=2.16u w=0.74u l=0.13u
X2 VDD B a_192_429# VDD sg13_lv_pmos ad=0.2891p pd=1.695u as=0.1596p ps=1.22u w=0.84u l=0.13u
X3 a_435_412# A VDD VDD sg13_lv_pmos ad=0.1428p pd=1.375u as=0.2891p ps=1.695u w=1.12u l=0.13u
X4 a_155_160# A VSS VSS sg13_lv_nmos ad=78.39999f pd=0.885u as=0.2272p ps=1.99u w=0.64u l=0.13u
X5 a_341_118# B VSS VSS sg13_lv_nmos ad=0.1406p pd=1.12u as=0.1898p ps=1.36u w=0.74u l=0.13u
X6 Y a_192_429# a_341_118# VSS sg13_lv_nmos ad=0.2516p pd=2.16u as=0.1406p ps=1.12u w=0.74u l=0.13u
X7 VDD a_192_429# Y VDD sg13_lv_pmos ad=0.3808p pd=2.92u as=0.2408p ps=1.55u w=1.12u l=0.13u
X8 Y B a_435_412# VDD sg13_lv_pmos ad=0.2408p pd=1.55u as=0.1428p ps=1.375u w=1.12u l=0.13u
X9 a_192_429# B a_155_160# VSS sg13_lv_nmos ad=0.2176p pd=1.96u as=78.39999f ps=0.885u w=0.64u l=0.13u
C0 B VDD 0.22536f
C1 B a_192_429# 0.37671f
C2 VDD a_192_429# 0.26739f
C3 a_192_429# a_155_160# 0.01136f
C4 a_341_118# Y 0.03585f
C5 B Y 0.12216f
C6 B A 0.3854f
C7 VDD Y 0.34215f
C8 Y a_192_429# 0.20974f
C9 a_341_118# a_192_429# 0.33494f
C10 VDD A 0.13379f
C11 A a_192_429# 0.11286f
C12 Y VSS 0.10343f
C13 B VSS 0.42693f
C14 A VSS 0.60952f
C15 VDD VSS 0.23595f
C16 a_341_118# VSS 0.13897f $ **FLOATING
C17 a_192_429# VSS 0.49842f $ **FLOATING
.ends
