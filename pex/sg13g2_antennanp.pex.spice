* NGSPICE file created from sg13g2_antennanp_flat.ext - technology: ihp-sg13g2

.subckt sg13g2_antennanp_flat A VSS VDD
X0 A VDD dpantenna l=1.05u w=2.16u
X1 VSS A dantenna l=0 w=0
C0 A VDD 0.05512f
C1 A VSS 0.20474f
C2 VDD VSS 0.08333f
.ends
