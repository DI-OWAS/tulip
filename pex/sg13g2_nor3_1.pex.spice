* NGSPICE file created from sg13g2_nor3_1_flat.ext - technology: ihp-sg13g2

.subckt sg13g2_nor3_1_flat A Y B C VDD VSS
X0 a_254_412# B a_165_412# VDD sg13_lv_pmos ad=0.182p pd=1.445u as=0.1764p ps=1.435u w=1.12u l=0.13u
X1 Y C a_254_412# VDD sg13_lv_pmos ad=0.3808p pd=2.92u as=0.182p ps=1.445u w=1.12u l=0.13u
X2 Y A VSS VSS sg13_lv_nmos ad=0.1694p pd=1.21u as=0.2618p ps=2.22u w=0.77u l=0.13u
X3 a_165_412# A VDD VDD sg13_lv_pmos ad=0.1764p pd=1.435u as=0.3808p ps=2.92u w=1.12u l=0.13u
X4 VSS B Y VSS sg13_lv_nmos ad=0.1463p pd=1.15u as=0.1694p ps=1.21u w=0.77u l=0.13u
X5 Y C VSS VSS sg13_lv_nmos ad=0.2618p pd=2.22u as=0.1463p ps=1.15u w=0.77u l=0.13u
C0 C VDD 0.06952f
C1 Y a_254_412# 0.02084f
C2 Y a_165_412# 0.01904f
C3 Y B 0.26521f
C4 A VDD 0.12082f
C5 C B 0.12239f
C6 Y C 0.15352f
C7 A B 0.04487f
C8 Y A 0.11813f
C9 VDD B 0.05327f
C10 Y VDD 0.20242f
C11 Y VSS 0.33664f
C12 C VSS 0.29342f
C13 B VSS 0.24095f
C14 A VSS 0.3443f
C15 VDD VSS 0.1573f
.ends
