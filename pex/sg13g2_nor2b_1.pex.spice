* NGSPICE file created from sg13g2_nor2b_1_flat.ext - technology: ihp-sg13g2

.subckt sg13g2_nor2b_1_flat A B_N VDD Y VSS
X0 VDD B_N a_46_156# VDD sg13_lv_pmos ad=0.2618p pd=1.63u as=0.2856p ps=2.36u w=0.84u l=0.13u
X1 VSS B_N a_46_156# VSS sg13_lv_nmos ad=0.17255p pd=1.25u as=0.187p ps=1.78u w=0.55u l=0.13u
X2 Y a_46_156# VSS VSS sg13_lv_nmos ad=0.1406p pd=1.12u as=0.17255p ps=1.25u w=0.74u l=0.13u
X3 VSS A Y VSS sg13_lv_nmos ad=0.2516p pd=2.16u as=0.1406p ps=1.12u w=0.74u l=0.13u
X4 a_268_412# a_46_156# VDD VDD sg13_lv_pmos ad=0.1176p pd=1.33u as=0.2618p ps=1.63u w=1.12u l=0.13u
X5 Y A a_268_412# VDD sg13_lv_pmos ad=0.3808p pd=2.92u as=0.1176p ps=1.33u w=1.12u l=0.13u
C0 A VDD 0.06952f
C1 Y a_46_156# 0.24607f
C2 B_N a_46_156# 0.21995f
C3 Y VDD 0.08816f
C4 a_46_156# VDD 0.18533f
C5 B_N VDD 0.0645f
C6 Y a_268_412# 0.01266f
C7 Y A 0.19029f
C8 A a_46_156# 0.05666f
C9 Y VSS 0.21396f
C10 B_N VSS 0.23136f
C11 A VSS 0.31309f
C12 VDD VSS 0.13831f
C13 a_46_156# VSS 0.4018f $ **FLOATING
.ends
