* Converted from Spectre av_extracted (sg13g2_stdcell_rc_HU_v2.scs)
* Cell: sg13g2_dfrbp_1   Ports: Q Q_N CLK D RESET_B VDD VSS
.subckt sg13g2_sdfrbp_2_flat Q Q_N CLK D RESET_B SCD SCE VDD VSS
XN19 SCEb_6 SCE_5 VSS_14 VSS_2 sg13_lv_nmos w=5.5e-07  l=1.3e-07 ng=1 ad=1.87e-13 as=1.8945e-13 pd=1.78e-06 ps=1.27e-06  m=1
CC1 CLK VSS 9.52495e-18
CC2 Q_N VSS 5.05789e-17
CC3 RESET_B VSS 6.41421e-18
CC4 SCD VSS 2.57654e-18
CC5 VDD VSS 3.71376e-16
CC6 SCEb VSS 3.69282e-17
CC7 Db VSS 2.99846e-17
CC8 Dbb VSS 3.4886e-17
CC9 Dbbb VSS 8.07853e-18
CC10 net4 VSS 7.98781e-17
CC11 net6 VSS 6.39767e-17
CC12 clkneg VSS 2.813e-17
CC13 clkpos VSS 1.22885e-16
CC14 net5 VSS 1.26147e-16
CC15 net2 VSS 5.49833e-17
CC16 net1 VSS 7.34461e-17
CC17 net65 VSS 3.74473e-19
CC18 net9 VSS 1.39748e-16
CC19 net12 VSS 9.91119e-18
CC20 net1_9 VSS 6.60653e-18
CC21 net5_5 VSS 1.21897e-17
CC22 net5_11 VSS 5.31809e-17
CC23 RESET_B_10 VSS 1.21853e-16
CC24 clkpos_10 VSS 2.81575e-17
CC25 clkneg_13 VSS 3.33601e-17
CC26 CLK_3 VSS 2.13775e-17
CC27 clkneg_3 VSS 1.0873e-16
CC28 clkpos_4 VSS 4.4247e-17
CC29 clkneg_4 VSS 1.89224e-16
CC30 net4_3 VSS 8.60431e-17
CC31 RESET_B_7 VSS 9.71669e-17
CC32 RESET_B_8 VSS 1.18183e-16
CC33 Dbb_7 VSS 4.20124e-17
CC34 Db_6 VSS 2.39342e-17
CC35 SCEb_3 VSS 2.64239e-17
CC36 D_1 VSS 1.38877e-17
CC37 SCD_1 VSS 2.69374e-17
CC38 SCE_4 VSS 1.65162e-17
CC39 SCE_5 VSS 1.09468e-17
CC40 net1_10 VSS 7.01883e-18
CC41 net5_12 VSS 7.72293e-18
CC42 net5_14 VSS 8.996e-19
CC43 net5_16 VSS 1.43575e-17
CC44 net5_17 VSS 2.38268e-17
CC45 RESET_B_11 VSS 9.58918e-17
CC46 net2_3 VSS 4.2739e-17
CC47 clkpos_9 VSS 5.6806e-17
CC48 clkneg_11 VSS 2.07994e-17
CC49 CLK_1 VSS 1.93035e-17
CC50 clkpos_3 VSS 3.91685e-17
CC51 clkneg_5 VSS 9.54109e-17
CC52 RESET_B_5 VSS 5.37042e-17
CC53 net6_3 VSS 3.53309e-17
CC54 RESET_B_9 VSS 1.11155e-16
CC55 Dbb_5 VSS 2.68256e-17
CC56 Db_5 VSS 2.99792e-17
CC57 SCD_3 VSS 3.40345e-17
CC58 D_3 VSS 3.09174e-17
CC59 SCE_1 VSS 8.76993e-18
CC60 RESET_B_12 VSS 1.16279e-16
CC61 net2_2 VSS 1.50934e-16
CC62 clkpos_5 VSS 1.40996e-16
CC63 clkneg_6 VSS 1.15742e-16
CC64 clkneg_2 VSS 1.20308e-16
CC65 RESET_B_4 VSS 3.41973e-16
CC66 net4_2 VSS 2.05007e-16
CC67 RESET_B_3 VSS 1.87103e-16
CC68 net6_4 VSS 3.99881e-18
CC69 Db_4 VSS 1.30709e-16
CC70 SCEb_2 VSS 1.20274e-16
CC71 SCD_4 VSS 1.21124e-16
CC72 D_2 VSS 1.46801e-16
CC73 SCD_2 VSS 1.20494e-16
CC74 SCE_3 VSS 6.34897e-17
CC75 VDD_1 VSS 1.81895e-18
CC76 VDD_13 VSS 2.19013e-18
CC77 Q_2 VSS 2.02996e-18
CC78 VDD_14 VSS 4.53482e-18
CC79 net1_3 VSS 4.97507e-18
CC80 VDD_15 VSS 8.05922e-18
CC81 Q_N_2 VSS 1.95902e-18
CC82 VDD_16 VSS 1.13557e-17
CC83 net2_4 VSS 1.82563e-17
CC84 net4_9 VSS 1.34852e-18
CC85 net5_3 VSS 4.48081e-19
CC86 net12_2 VSS 3.51569e-17
CC87 clkneg_10 VSS 3.65204e-17
CC88 net5_4 VSS 9.67128e-18
CC89 net4_4 VSS 4.33213e-17
CC90 clkneg_7 VSS 3.98031e-18
CC91 clkpos_6 VSS 1.59704e-17
CC92 clkpos_8 VSS 1.37111e-17
CC93 net6_8 VSS 2.94216e-18
CC94 Dbbb_6 VSS 1.1376e-17
CC95 net9_2 VSS 1.05357e-16
CC96 net4_10 VSS 1.60444e-17
CC97 Dbbb_3 VSS 2.44382e-17
CC98 Dbb_3 VSS 4.08209e-17
CC99 Db_2 VSS 9.05644e-18
CC100 SCEb_6 VSS 2.75941e-17
CC101 Dbbb_4 VSS 6.34348e-17
CC102 net6_5 VSS 1.82769e-18
CC103 VDD_17 VSS 1.66644e-18
CC104 net4_8 VSS 2.54776e-18
CC105 VDD_20 VSS 5.16428e-18
CC106 VDD_21 VSS 2.59658e-18
CC107 VDD_12 VSS 2.62569e-17
CC108 SCEb_4 VSS 1.31173e-17
CC109 SCE_2 VSS 9.50699e-17
CC110 SCE_7 VSS 5.39808e-18
CC111 SCE_9 VSS 3.43524e-19
CC112 D_5 VSS 5.03735e-18
CC113 D_6 VSS 6.58377e-18
CC114 Dbb_2 VSS 2.09004e-17
CC115 Dbb_6 VSS 9.26105e-17
CC116 net6_2 VSS 9.06606e-17
CC117 net6_6 VSS 2.1408e-17
CC118 net6_7 VSS 2.11855e-17
CC119 clkpos_2 VSS 1.09188e-16
CC120 CLK_2 VSS 8.68807e-17
CC121 clkneg_12 VSS 6.05458e-17
CC122 net4_5 VSS 4.7585e-16
CC123 net4_6 VSS 3.38438e-16
CC124 net4_7 VSS 1.95462e-17
CC125 net5_2 VSS 3.54878e-17
CC126 net2_5 VSS 1.10844e-17
CC127 net5_7 VSS 8.87317e-17
CC128 net5_9 VSS 5.95802e-17
CC129 net5_10 VSS 4.25991e-17
CC130 net1_2 VSS 1.6608e-17
CC131 net1_6 VSS 4.86767e-17
CC132 net1_7 VSS 2.09667e-17
CC133 Q_1 VSS 3.95485e-17
CC134 VDD_2 VSS 2.61155e-19
CC135 VDD_3 VSS 1.15149e-18
CC136 VDD_4 VSS 1.41029e-18
CC137 VDD_6 VSS 3.60387e-17
CC138 VDD_8 VSS 2.94633e-17
CC139 VDD_9 VSS 9.16429e-18
CC140 VDD_10 VSS 5.87215e-19
RRg34 CLK CLK_4 0.0385
RRg8 D_2 D_4 15
RRg5 D_4 D_5 0.008462
RRg6 D_6 D 0.008462
RRg7 D_5 D_6 0.0212
RRg64 Q Q_1 0.01496
RRg65 Q_1 Q_2 5.6762
RRg66 Q_1 Q_3 7.6311
RRg60 Q_N Q_N_2 5.5895
RRg59 Q_N_1 Q_N 7.6595
RRg52 RESET_B_12 RESET_B_4 3.4168
RRg20 RESET_B RESET_B_1 0.0105
RRg21 RESET_B_2 RESET_B_3 0.0105
RRg22 RESET_B_1 RESET_B_2 0.03989
RRg10 SCD SCD_4 0.143
RRg9 SCD SCD_2 0.8868
RRg4 SCE_3 SCE_8 15
RRg1 SCE_7 SCE_8 0.005851
RRg2 SCE SCE_9 0.005851
RRg3 SCE_7 SCE_9 0.02676
RRg91 VDD_1 VDD_2 15.1106
RRg103 VDD_2 VDD_13 5.4268
RRg104 VDD_3 VDD_14 5.4268
RRg92 VDD_2 VDD_3 0.2525
RRg105 VDD_4 VDD_15 5.4987
RRg93 VDD_3 VDD_4 0.2675
RRg111 VDD_1 VDD_5 1.1538
RRg94 VDD_4 VDD_5 0.1981
RRg106 VDD_6 VDD_16 7.8676
RRg95 VDD_5 VDD_6 0.05311
RRg97 VDD_7 VDD 0.1088
RRg112 VDD_1 VDD_7 1.1538
RRg96 VDD_6 VDD_7 1.5031
RRg98 VDD VDD_8 0.2728
RRg107 VDD_8 VDD_17 15.4129
RRg99 VDD_8 VDD_9 0.6691
RRg110 VDD_10 VDD_21 5.5911
RRg100 VDD_9 VDD_10 0.3501
RRg113 VDD_1 VDD_11 1.1538
RRg102 VDD_11 VDD_12 15.8277
RRg101 VDD_10 VDD_11 0.1513
RRg114 VDD_18 VDD_19 15
RRg109 VDD_19 VDD_20 15.3775
RRg108 VDD_9 VDD_19 0.1657
RRg87 VSS_2 VSS_3 15
RRg67 VSS_1 VSS_3 15.254
RRg80 VSS_4 VSS_15 7.8126
RRg68 VSS_3 VSS_4 0.2731
RRg81 VSS_5 VSS_16 15.2406
RRg69 VSS_4 VSS_5 0.2512
RRg82 VSS_6 VSS_17 15.2611
RRg70 VSS_5 VSS_6 0.2489
RRg88 VSS_2 VSS_7 1.1538
RRg71 VSS_6 VSS_7 0.05584
RRg73 VSS_8 VSS 0.7281
RRg83 VSS_8 VSS_18 15.2554
RRg72 VSS_7 VSS_8 0.2756
RRg74 VSS VSS_9 0.5525
RRg89 VSS_2 VSS_9 1.1538
RRg84 VSS_10 VSS_19 15.2681
RRg75 VSS_9 VSS_10 0.5469
RRg85 VSS_11 VSS_20 15.2554
RRg76 VSS_10 VSS_11 0.27
RRg86 VSS_12 VSS_21 15.2491
RRg77 VSS_11 VSS_12 0.5812
RRg90 VSS_2 VSS_13 1.1538
RRg79 VSS_13 VSS_14 8.4076
RRg78 VSS_12 VSS_13 0.1506
RRg11 SCEb_2 SCEb_5 18.1886
RRg12 SCEb_5 SCEb_6 16.0191
RRg13 SCEb_4 SCEb_5 7.5
RRg15 Db_3 Db_4 16.478
RRg16 Db_2 Db_3 15
RRg14 Db Db_3 9.5537
RRg17 Dbb Dbb_2 15.2519
RRg18 Dbb_2 Dbb_3 7.8615
RRg19 Dbb_2 Dbb_4 5.3994
RRg28 Dbbb_2 Dbbb_3 16.3438
RRg31 Dbbb Dbbb_2 15
RRg30 Dbbb_5 Dbbb_6 16.6116
RRg32 Dbbb_4 Dbbb_5 15
RRg29 Dbbb_2 Dbbb_5 3.3796
RRg48 net4_5 net4_9 15.9348
RRg44 net4_4 net4_5 16.386
RRg49 net4_6 net4_2 15.4952
RRg45 net4_5 net4_6 3.3474
RRg50 net4_7 net4_10 15.0891
RRg47 net4_7 net4_8 16.5474
RRg46 net4_6 net4_7 0.6336
RRg26 net6_6 net6_8 15.3341
RRg23 net6_5 net6_6 15.2609
RRg25 net6_7 net6_4 0.5275
RRg27 net6_7 net6_9 15.2851
RRg24 net6_6 net6_7 1.0159
RRg35 clkneg_6 clkneg_8 15.2171
RRg39 clkneg_7 clkneg_8 15
RRg37 clkneg_9 clkneg_2 15.0502
RRg38 clkneg_9 clkneg_10 15.9853
RRg36 clkneg_8 clkneg_9 0.7443
RRg42 clkpos clkpos_8 15.4055
RRg40 clkpos_5 clkpos_7 17.5422
RRg41 clkpos_7 clkpos 0.1666
RRg43 clkpos_6 clkpos_7 7.5
RRg53 net5 net5_2 15.7583
RRg54 net5_2 net5_3 15.5604
RRg55 net5_2 net5_4 15.71
RRg57 net2_5 net2_2 15.6288
RRg58 net2_5 net2_6 15.0446
RRg56 net2_4 net2_5 16.294
RRg61 net1 net1_2 15.1211
RRg62 net1_2 net1_3 5.3783
RRg63 net1_2 net1_4 7.7555
RRg33 net9 net9_2 31.272
RRg51 net12 net12_2 31.1684
RRh36 CLK_2 CLK_3 15.1699
RRh35 CLK_1 CLK_2 18.1314
RRh37 CLK_2 CLK_4 17.9905
RRh7 D_1 D_2 11.3175
RRh8 D_2 D_3 20.4615
RRh25 RESET_B_7 RESET_B_8 112.788
RRh45 RESET_B_10 RESET_B_11 64.6196
RRh26 RESET_B_8 RESET_B_9 56.4598
RRh46 RESET_B_11 RESET_B_12 52.7375
RRh22 RESET_B_4 RESET_B_5 165.521
RRh24 RESET_B_6 RESET_B_7 38.721
RRh23 RESET_B_5 RESET_B_6 34.9624
RRh27 RESET_B_3 RESET_B_6 15
RRh9 SCD_3 SCD_4 35.2604
RRh6 SCD_1 SCD_2 24.2086
RRh4 SCE_3 SCE_5 17.2308
RRh5 SCE_3 SCE_6 13.4615
RRh3 SCE_2 SCE_4 20.9678
RRh1 SCE_1 SCE_2 16.6601
RRh2 SCE_2 SCE_3 9.1417
RRh11 SCEb_2 SCEb_3 15.6787
RRh10 SCEb SCEb_2 14.8139
RRh13 Db_4 Db_6 14.6018
RRh12 Db_5 Db_4 15.8908
RRh16 Dbb_6 Dbb_7 33.1615
RRh14 Dbb_5 Dbb_6 28.3153
RRh15 Dbb_6 Dbb 1.7627
RRh21 net4_2 net4_3 36.6702
RRh20 net4 net4_2 37.889
RRh17 net6 net6_2 15.4014
RRh18 net6_2 net6_3 16.0783
RRh19 net6_2 net6_4 15.5961
RRh33 clkneg_3 clkneg_4 137.092
RRh34 clkneg_4 clkneg_5 38.9296
RRh32 clkneg_2 clkneg_3 14.4487
RRh31 clkneg clkneg_2 13.5699
RRh40 clkneg_12 clkneg_13 30.3206
RRh38 clkneg_11 clkneg_12 16.3913
RRh39 clkneg_12 clkneg_6 20.0382
RRh42 clkpos_5 clkpos_10 7.7168
RRh41 clkpos_9 clkpos_5 30.889
RRh30 clkpos_2 clkpos_4 32.2576
RRh29 clkpos_2 clkpos_3 8.7038
RRh28 clkpos clkpos_2 49.9533
RRh53 net5 net5_11 24.0163
RRh59 net5 net5_17 27.5163
RRh47 net5_5 net5_6 40.9612
RRh54 net5_6 net5_12 17.6512
RRh55 net5_7 net5_13 16.0358
RRh48 net5_6 net5_7 6.7925
RRh56 net5_8 net5_14 17.6512
RRh49 net5_7 net5_8 20.254
RRh57 net5_9 net5_15 16.0358
RRh50 net5_8 net5_9 6.7925
RRh58 net5_10 net5_16 15.444
RRh52 net5_10 net5 23.2099
RRh51 net5_9 net5_10 21.7052
RRh43 net2 net2_2 36.0571
RRh44 net2_2 net2_3 11.7982
RRh65 net1 net1_10 15.9394
RRh60 net1_5 net1_6 30.5124
RRh63 net1_6 net1_8 22.8032
RRh64 net1_7 net1_9 11.7648
RRh62 net1_7 net1 18.85
RRh61 net1_6 net1_7 6.7516
XP20 SCEb_4 SCE_6 VDD_12 VDD sg13_lv_pmos w=8.4e-07 l=1.3e-07  ng=1 ad=2.856e-13 as=2.53e-13 pd=2.36e-06 ps=1.53e-06 m=1
XP22 net64 SCE_1 VDD_12 VDD sg13_lv_pmos w=1e-06 l=1.3e-07 ng=1  ad=3.325e-13 as=2.53e-13 pd=1.665e-06 ps=1.53e-06 m=1
XP17 Db D_3 net64 VDD sg13_lv_pmos w=1e-06 l=1.3e-07 ng=1  ad=2.225e-13 as=3.325e-13 pd=1.445e-06 ps=1.665e-06 m=1
XP18 Db SCD_3 net62 VDD sg13_lv_pmos w=1e-06 l=1.3e-07 ng=1  ad=2.225e-13 as=2.975e-13 pd=1.445e-06 ps=1.595e-06 m=1
XP21 net62 SCEb VDD_21 VDD sg13_lv_pmos w=1e-06 l=1.3e-07 ng=1  ad=2.975e-13 as=2.198e-13 pd=1.595e-06 ps=1.52e-06 m=1
XP11 net4_8 net6_3 VDD_18 VDD sg13_lv_pmos w=1e-06 l=1.3e-07  ng=1 ad=3.4e-13 as=3.62387e-13 pd=2.68e-06 ps=2.605e-06 m=1
XP12 net4_4 clkneg_11 net5_4 VDD sg13_lv_pmos w=1e-06  l=1.3e-07 ng=1 ad=3.4e-13 as=1.9115e-13 pd=2.68e-06 ps=1.565e-06  m=1
XP5 net1_3 net5_12 VDD_15 VDD sg13_lv_pmos w=1e-06 l=1.3e-07  ng=1 ad=3.4e-13 as=2.083e-13 pd=2.68e-06 ps=1.5e-06 m=1
XP23 Dbb_4 Db_5 VDD_21 VDD sg13_lv_pmos w=1.12e-06 l=1.3e-07  ng=1 ad=6.048e-13 as=2.198e-13 pd=3.32e-06 ps=1.52e-06 m=1
XP3 clkpos_6 clkneg VDD_1 VDD sg13_lv_pmos w=1.12e-06 l=1.3e-07  ng=1 ad=3.864e-13 as=4.31025e-13 pd=2.93e-06 ps=2.145e-06 m=1
XP2 clkneg_7 CLK_1 VDD_1 VDD sg13_lv_pmos w=1.12e-06  l=1.3e-07 ng=1 ad=3.808e-13 as=4.31025e-13 pd=2.92e-06  ps=2.145e-06 m=1
XP6 Q_N_2 net5_16 VDD_16 VDD sg13_lv_pmos w=1.12e-06  l=1.3e-07 ng=1 ad=2.128e-13 as=2.014e-13 pd=1.5e-06 ps=1.53e-06  m=1
XP6_1__rcx Q_N_2 net5_14 VDD_15 VDD sg13_lv_pmos w=1.12e-06  l=1.3e-07 ng=1 ad=2.128e-13 as=2.083e-13 pd=1.5e-06 ps=1.5e-06 m=1
XP4_1__rcx Q_2 net1_10 VDD_14 VDD sg13_lv_pmos w=1.12e-06  l=1.3e-07 ng=1 ad=2.156e-13 as=3.808e-13 pd=1.505e-06 ps=2.92e-06  m=1
XP4 Q_2 net1_8 VDD_13 VDD sg13_lv_pmos w=1.12e-06 l=1.3e-07  ng=1 ad=2.156e-13 as=3.808e-13 pd=1.505e-06 ps=2.92e-06 m=1
XP1 Dbbb Dbb_5 VDD_20 VDD sg13_lv_pmos w=4.2e-07 l=1.3e-07 ng=1  ad=7.98e-14 as=1.428e-13 pd=8e-07 ps=1.52e-06 m=1
XP0 Dbbb RESET_B_9 VDD_18 VDD sg13_lv_pmos w=4.2e-07 l=1.3e-07  ng=1 ad=7.98e-14 as=3.62387e-13 pd=8e-07 ps=2.605e-06 m=1
XP10 net6_9 RESET_B_5 VDD_17 VDD sg13_lv_pmos w=4.2e-07  l=1.3e-07 ng=1 ad=1.47e-13 as=1.563e-13 pd=1.54e-06 ps=1.22e-06  m=1
XP8 net7 net4 VDD_17 VDD sg13_lv_pmos w=4.2e-07 l=1.3e-07 ng=1  ad=5.46e-14 as=1.563e-13 pd=6.8e-07 ps=1.22e-06 m=1
XP9 net6_5 clkneg_5 net7 VDD sg13_lv_pmos w=4.2e-07 l=1.3e-07  ng=1 ad=7.98e-14 as=5.46e-14 pd=8e-07 ps=6.8e-07 m=1
XP7 Dbbb_4 clkpos_3 net6_5 VDD sg13_lv_pmos w=4.2e-07  l=1.3e-07 ng=1 ad=1.428e-13 as=7.98e-14 pd=1.52e-06 ps=8e-07 m=1
XP14 net5_4 clkpos_9 net3 VDD sg13_lv_pmos w=4.2e-07 l=1.3e-07  ng=1 ad=1.9115e-13 as=5.25e-14 pd=1.565e-06 ps=6.7e-07 m=1
XP13 net3 net2_3 VDD_1 VDD sg13_lv_pmos w=4.2e-07 l=1.3e-07  ng=1 ad=5.25e-14 as=2.5605e-13 pd=6.7e-07 ps=1.935e-06 m=1
XP16 net2_6 RESET_B_11 VDD_1 VDD sg13_lv_pmos w=4.2e-07  l=1.3e-07 ng=1 ad=7.98e-14 as=2.5605e-13 pd=8e-07 ps=1.935e-06 m=1
XP15 net2_6 net5_17 VDD_16 VDD sg13_lv_pmos w=4.2e-07  l=1.3e-07 ng=1 ad=7.98e-14 as=2.014e-13 pd=8e-07 ps=1.53e-06 m=1
XN18 net63 SCE_4 VSS_14 VSS_2 sg13_lv_nmos w=7.4e-07  l=1.3e-07 ng=1 ad=1.3135e-13 as=1.8945e-13 pd=1.095e-06  ps=1.27e-06 m=1
XN22 Db_2 SCD_1 net63 VSS_2 sg13_lv_nmos w=7.4e-07 l=1.3e-07  ng=1 ad=1.628e-13 as=1.3135e-13 pd=1.18e-06 ps=1.095e-06 m=1
XN21 Db_2 D_1 net65 VSS_2 sg13_lv_nmos w=7.4e-07 l=1.3e-07  ng=1 ad=1.628e-13 as=3.367e-13 pd=1.18e-06 ps=1.65e-06 m=1
XN17 net65 SCEb_3 VSS_21 VSS_2 sg13_lv_nmos w=7.4e-07  l=1.3e-07 ng=1 ad=3.367e-13 as=1.48e-13 pd=1.65e-06 ps=1.14e-06  m=1
XN23 Dbb_3 Db_6 VSS_21 VSS_2 sg13_lv_nmos w=7.4e-07  l=1.3e-07 ng=1 ad=4.033e-13 as=1.48e-13 pd=2.57e-06 ps=1.14e-06  m=1
XN11 net4_10 net6 VSS_20 VSS_2 sg13_lv_nmos w=7.4e-07  l=1.3e-07 ng=1 ad=2.516e-13 as=1.626e-13 pd=2.16e-06 ps=1.415e-06  m=1
XN3 clkpos_8 clkneg_3 VSS_2 VSS_2 sg13_lv_nmos w=7.4e-07  l=1.3e-07 ng=1 ad=2.516e-13 as=4.3315e-13 pd=2.16e-06 ps=2.205e-06  m=1
XN2 clkneg_10 CLK_3 VSS_2 VSS_2 sg13_lv_nmos w=7.4e-07  l=1.3e-07 ng=1 ad=2.516e-13 as=4.3315e-13 pd=2.16e-06 ps=2.205e-06  m=1
XN12 net4_9 clkpos_10 net5_3 VSS_2 sg13_lv_nmos w=7.4e-07  l=1.3e-07 ng=1 ad=3.473e-13 as=1.2665e-13 pd=2.71e-06 ps=1.145e-06  m=1
XN6_1__rcx Q_N_1 net5_15 VSS_17 VSS_2 sg13_lv_nmos w=7.4e-07 l=1.3e-07 ng=1 ad=1.406e-13 as=2.516e-13 pd=1.12e-06  ps=2.16e-06 m=1
XN6 Q_N_1 net5_13 VSS_16 VSS_2 sg13_lv_nmos w=7.4e-07  l=1.3e-07 ng=1 ad=1.406e-13 as=1.331e-13 pd=1.12e-06 ps=1.12e-06  m=1
XN4 Q_3 net1_9 VSS_15 VSS_2 sg13_lv_nmos w=7.4e-07  l=1.3e-07 ng=1 ad=1.406e-13 as=2.516e-13 pd=1.12e-06 ps=2.16e-06  m=1
XN4_1__rcx Q_3 net1_5 VSS_1 VSS_2 sg13_lv_nmos w=7.4e-07  l=1.3e-07 ng=1 ad=1.406e-13 as=2.516e-13 pd=1.12e-06 ps=2.16e-06  m=1
XN0 Dbbb_3 Dbb_7 net10 VSS_2 sg13_lv_nmos w=4.2e-07 l=1.3e-07  ng=1 ad=1.428e-13 as=6.09e-14 pd=1.52e-06 ps=7.1e-07 m=1
XN1 net10 RESET_B_8 VSS_20 VSS_2 sg13_lv_nmos w=4.2e-07  l=1.3e-07 ng=1 ad=6.09e-14 as=1.626e-13 pd=7.1e-07 ps=1.415e-06  m=1
XN10 net8 RESET_B_7 VSS_19 VSS_2 sg13_lv_nmos w=4.2e-07  l=1.3e-07 ng=1 ad=3.885e-14 as=1.701e-13 pd=6.05e-07 ps=1.65e-06  m=1
XN9 net9_2 net4_3 net8 VSS_2 sg13_lv_nmos w=4.2e-07 l=1.3e-07  ng=1 ad=1.596e-13 as=3.885e-14 pd=1.6e-06 ps=6.05e-07 m=1
XN7 Dbbb_6 clkneg_4 net6_8 VSS_2 sg13_lv_nmos w=4.2e-07  l=1.3e-07 ng=1 ad=1.296e-13 as=8.1e-14 pd=1.52e-06 ps=8.1e-07 m=1
XN8 net6_8 clkpos_4 net9 VSS_2 sg13_lv_nmos w=4.2e-07  l=1.3e-07 ng=1 ad=8.1e-14 as=2.163e-13 pd=8.1e-07 ps=1.87e-06 m=1
XN14 net5_3 clkneg_13 net12_2 VSS_2 sg13_lv_nmos w=4.2e-07  l=1.3e-07 ng=1 ad=1.2665e-13 as=1.428e-13 pd=1.145e-06 ps=1.52e-06  m=1
XN13 net12 net2 VSS_18 VSS_2 sg13_lv_nmos w=4.2e-07 l=1.3e-07  ng=1 ad=1.428e-13 as=7.98e-14 pd=1.52e-06 ps=8e-07 m=1
XN16 net11 RESET_B_10 VSS_18 VSS_2 sg13_lv_nmos w=4.2e-07  l=1.3e-07 ng=1 ad=3.78e-14 as=7.98e-14 pd=6e-07 ps=8e-07 m=1
XN15 net2_4 net5_11 net11 VSS_2 sg13_lv_nmos w=4.2e-07  l=1.3e-07 ng=1 ad=1.428e-13 as=3.78e-14 pd=1.52e-06 ps=6e-07 m=1
XN5 net1_4 net5_5 VSS_16 VSS_2 sg13_lv_nmos w=6.4e-07  l=1.3e-07 ng=1 ad=2.176e-13 as=1.331e-13 pd=1.96e-06 ps=1.12e-06  m=1
.ends sg13g2_sdfrbp_2_flat

* Converted from Spectre av_extracted (sg13g2_stdcell_rc_HU_v2.scs)
* Cell: sg13g2_dlhr_1   Ports: Q Q_N D GATE RESET_B VDD VSS
