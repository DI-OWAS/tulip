* Converted from Spectre av_extracted (sg13g2_stdcell_rc_HU_v2.scs)
* Cell: sg13g2_dfrbp_1   Ports: Q Q_N CLK D RESET_B VDD VSS
.subckt sg13g2_sdfrbp_1_flat Q Q_N CLK D RESET_B SCD SCE VDD VSS
XN19 SCEb_6 SCE_5 VSS_11 VSS_3 sg13_lv_nmos w=5.5e-07  l=1.3e-07 ng=1 ad=1.87e-13 as=1.8945e-13 pd=1.78e-06 ps=1.27e-06  m=1
CC1 CLK VSS 9.52495e-18
CC2 Q VSS 4.66951e-17
CC3 RESET_B VSS 6.41421e-18
CC4 VDD VSS 3.51991e-16
CC5 SCEb VSS 3.69309e-17
CC6 Db VSS 2.99697e-17
CC7 Dbb VSS 9.0098e-18
CC8 net4 VSS 7.98781e-17
CC9 net6 VSS 6.39774e-17
CC10 clkneg VSS 2.813e-17
CC11 clkpos VSS 1.22885e-16
CC12 net5 VSS 1.21859e-16
CC13 net2 VSS 5.49817e-17
CC14 net65 VSS 3.7444e-19
CC15 net9 VSS 1.39748e-16
CC16 net12 VSS 9.91119e-18
CC17 net1_6 VSS 6.31279e-18
CC18 net5_10 VSS 5.8728e-18
CC19 net5_9 VSS 5.31935e-17
CC20 RESET_B_10 VSS 1.21864e-16
CC21 clkpos_10 VSS 2.81575e-17
CC22 clkneg_13 VSS 3.33601e-17
CC23 CLK_3 VSS 2.13775e-17
CC24 clkneg_3 VSS 1.0873e-16
CC25 clkpos_4 VSS 4.4247e-17
CC26 clkneg_4 VSS 1.89224e-16
CC27 net4_3 VSS 8.60431e-17
CC28 RESET_B_7 VSS 9.71669e-17
CC29 RESET_B_8 VSS 1.18183e-16
CC30 net13_7 VSS 4.20124e-17
CC31 Db_6 VSS 2.39314e-17
CC32 SCEb_3 VSS 2.64211e-17
CC33 D_1 VSS 1.38849e-17
CC34 SCD_1 VSS 2.69346e-17
CC35 SCE_4 VSS 1.65162e-17
CC36 SCE_5 VSS 1.09468e-17
CC37 net1_4 VSS 6.78309e-18
CC38 net5_5 VSS 8.53501e-18
CC39 net5_12 VSS 1.43471e-17
CC40 net5_13 VSS 2.38268e-17
CC41 RESET_B_11 VSS 9.58918e-17
CC42 net2_3 VSS 4.2739e-17
CC43 clkpos_9 VSS 5.6806e-17
CC44 clkneg_11 VSS 2.07994e-17
CC45 CLK_1 VSS 1.93035e-17
CC46 clkpos_3 VSS 3.91685e-17
CC47 clkneg_5 VSS 9.54109e-17
CC48 RESET_B_5 VSS 5.37042e-17
CC49 net6_3 VSS 3.53309e-17
CC50 RESET_B_9 VSS 1.11155e-16
CC51 net13_5 VSS 2.68256e-17
CC52 Db_5 VSS 2.99818e-17
CC53 SCD_3 VSS 3.40345e-17
CC54 D_3 VSS 3.09174e-17
CC55 SCE_1 VSS 8.76993e-18
CC56 net1_2 VSS 9.43294e-17
CC57 RESET_B_12 VSS 1.16282e-16
CC58 net2_2 VSS 1.50934e-16
CC59 clkpos_5 VSS 1.40996e-16
CC60 clkneg_6 VSS 1.15744e-16
CC61 clkneg_2 VSS 1.20309e-16
CC62 RESET_B_4 VSS 3.42011e-16
CC63 net4_2 VSS 2.05028e-16
CC64 RESET_B_3 VSS 1.64138e-16
CC65 net6_4 VSS 3.99881e-18
CC66 net13_4 VSS 4.13216e-17
CC67 Db_4 VSS 1.30382e-16
CC68 SCEb_2 VSS 1.20274e-16
CC69 SCD_4 VSS 1.25672e-16
CC70 D_2 VSS 1.49196e-16
CC71 SCD_2 VSS 1.21789e-16
CC72 SCE_3 VSS 6.34893e-17
CC73 VDD_3 VSS 3.76405e-17
CC74 Q_1 VSS 1.06639e-19
CC75 VDD_1 VSS 8.52069e-18
CC76 VDD_11 VSS 8.23207e-18
CC77 Q_N_3 VSS 2.32631e-18
CC78 VDD_12 VSS 1.13557e-17
CC79 Q_2 VSS 3.71292e-19
CC80 net2_4 VSS 1.8539e-17
CC81 net4_9 VSS 1.34852e-18
CC82 net5_3 VSS 4.48081e-19
CC83 net12_2 VSS 3.51569e-17
CC84 clkneg_10 VSS 3.65204e-17
CC85 net5_4 VSS 9.67128e-18
CC86 net4_4 VSS 4.33213e-17
CC87 clkneg_7 VSS 3.98031e-18
CC88 clkpos_6 VSS 1.59704e-17
CC89 clkpos_8 VSS 1.37111e-17
CC90 net6_8 VSS 2.94216e-18
CC91 Dbb_6 VSS 1.1376e-17
CC92 net9_2 VSS 1.05357e-16
CC93 net4_10 VSS 1.60444e-17
CC94 Dbb_3 VSS 2.42346e-17
CC95 net13_3 VSS 4.08209e-17
CC96 Db_2 VSS 9.05875e-18
CC97 SCEb_6 VSS 2.75941e-17
CC98 Dbb_4 VSS 6.34464e-17
CC99 net6_5 VSS 1.82769e-18
CC100 VDD_13 VSS 1.66644e-18
CC101 net4_8 VSS 2.54776e-18
CC102 VDD_16 VSS 4.00911e-18
CC103 VDD_17 VSS 2.59658e-18
CC104 VDD_10 VSS 2.62569e-17
CC105 SCEb_4 VSS 1.3117e-17
CC106 SCE_2 VSS 9.50699e-17
CC107 SCE_7 VSS 5.33674e-18
CC108 SCE_9 VSS 4.04867e-19
CC109 D_5 VSS 5.62576e-18
CC110 D_6 VSS 5.96134e-18
CC111 net13_2 VSS 2.05868e-17
CC112 net13_6 VSS 9.79552e-17
CC113 net6_2 VSS 9.06606e-17
CC114 RESET_B_2 VSS 2.3049e-17
CC115 net6_6 VSS 2.1408e-17
CC116 net6_7 VSS 2.11855e-17
CC117 clkpos_2 VSS 1.09188e-16
CC118 CLK_2 VSS 8.68807e-17
CC119 clkneg_12 VSS 6.05521e-17
CC120 net4_5 VSS 4.75847e-16
CC121 net4_6 VSS 3.38491e-16
CC122 net4_7 VSS 1.95462e-17
CC123 net5_2 VSS 3.54878e-17
CC124 net2_5 VSS 1.12595e-17
CC125 Q_N_1 VSS 3.69905e-17
CC126 net5_6 VSS 8.83769e-17
CC127 net5_7 VSS 5.59634e-17
CC128 net5_8 VSS 5.00824e-17
CC129 net1_5 VSS 9.0553e-17
CC130 VDD_2 VSS 3.65572e-18
CC131 VDD_6 VSS 3.49628e-17
CC132 VDD_7 VSS 9.16429e-18
CC133 VDD_8 VSS 5.87215e-19
RRg34 CLK CLK_4 0.03025
RRg8 D_2 D_4 15
RRg5 D_4 D_5 0.007952
RRg6 D_6 D 0.007952
RRg7 D_5 D_6 0.01587
RRg64 Q_1 Q 5.4075
RRg65 Q Q_2 7.7863
RRg59 Q_N Q_N_1 0.0636
RRg61 Q_N_1 Q_N_3 5.5575
RRg60 Q_N_1 Q_N_2 7.6472
RRg52 RESET_B_12 RESET_B_4 3.4168
RRg20 RESET_B RESET_B_1 0.0105
RRg21 RESET_B_2 RESET_B_3 0.0105
RRg22 RESET_B_1 RESET_B_2 0.05198
RRg10 SCD SCD_4 0.04583
RRg9 SCD SCD_2 0.984
RRg4 SCE_3 SCE_8 15
RRg1 SCE_7 SCE_8 0.005266
RRg2 SCE SCE_9 0.005266
RRg3 SCE_7 SCE_9 0.02527
RRg66 VDD_1 VDD_2 5.6613
RRg75 VDD_2 VDD_11 5.4987
RRg81 VDD_3 VDD_4 1.25
RRg76 VDD_4 VDD_12 7.9315
RRg67 VDD_2 VDD_4 0.2581
RRg69 VDD_5 VDD 0.055
RRg82 VDD_3 VDD_5 1.1538
RRg68 VDD_4 VDD_5 1.5
RRg70 VDD VDD_6 0.3266
RRg77 VDD_6 VDD_13 15.4129
RRg71 VDD_6 VDD_7 0.6691
RRg80 VDD_8 VDD_17 5.5911
RRg72 VDD_7 VDD_8 0.3501
RRg83 VDD_3 VDD_9 1.1538
RRg74 VDD_9 VDD_10 15.8277
RRg73 VDD_8 VDD_9 0.1513
RRg84 VDD_14 VDD_15 15
RRg79 VDD_15 VDD_16 15.3775
RRg78 VDD_7 VDD_15 0.1657
RRg85 VSS_1 VSS_2 8.0794
RRg95 VSS_2 VSS_12 15.2406
RRg100 VSS_3 VSS_4 1.25
RRg86 VSS_2 VSS_4 0.2581
RRg96 VSS_5 VSS_13 15.2554
RRg87 VSS_4 VSS_5 0.2156
RRg89 VSS_6 VSS 0.0475
RRg101 VSS_3 VSS_6 1.1538
RRg88 VSS_5 VSS_6 1.2806
RRg90 VSS VSS_7 0.4994
RRg97 VSS_7 VSS_14 15.2681
RRg98 VSS_8 VSS_15 15.2554
RRg91 VSS_7 VSS_8 0.27
RRg99 VSS_9 VSS_16 15.2491
RRg92 VSS_8 VSS_9 0.5812
RRg102 VSS_3 VSS_10 1.1538
RRg94 VSS_10 VSS_11 8.4076
RRg93 VSS_9 VSS_10 0.1506
RRg11 SCEb_2 SCEb_5 18.1886
RRg12 SCEb_5 SCEb_6 16.0191
RRg13 SCEb_4 SCEb_5 7.5
RRg15 Db_3 Db_4 16.478
RRg16 Db_2 Db_3 15
RRg14 Db Db_3 9.5537
RRg19 net13_2 net13_4 15.2477
RRg18 net13_2 net13_3 7.8342
RRg17 net13 net13_2 5.4271
RRg28 Dbb_2 Dbb_3 16.3438
RRg31 Dbb Dbb_2 15
RRg30 Dbb_5 Dbb_6 16.6116
RRg32 Dbb_4 Dbb_5 15
RRg29 Dbb_2 Dbb_5 3.3796
RRg48 net4_5 net4_9 15.9348
RRg44 net4_4 net4_5 16.386
RRg49 net4_6 net4_2 15.4952
RRg45 net4_5 net4_6 3.3474
RRg50 net4_7 net4_10 15.0891
RRg47 net4_7 net4_8 16.5474
RRg46 net4_6 net4_7 0.6336
RRg26 net6_6 net6_8 15.3341
RRg23 net6_5 net6_6 15.2609
RRg25 net6_7 net6_4 0.5275
RRg27 net6_7 net6_9 15.2851
RRg24 net6_6 net6_7 1.0159
RRg35 clkneg_6 clkneg_8 15.2171
RRg39 clkneg_7 clkneg_8 15
RRg37 clkneg_9 clkneg_2 15.0502
RRg38 clkneg_9 clkneg_10 15.9853
RRg36 clkneg_8 clkneg_9 0.7443
RRg42 clkpos clkpos_8 15.4055
RRg40 clkpos_5 clkpos_7 17.5422
RRg41 clkpos_7 clkpos 0.1666
RRg43 clkpos_6 clkpos_7 7.5
RRg53 net5 net5_2 15.7583
RRg54 net5_2 net5_3 15.5604
RRg55 net5_2 net5_4 15.71
RRg57 net2_5 net2_2 15.6288
RRg58 net2_5 net2_6 15.0446
RRg56 net2_4 net2_5 16.294
RRg62 net1 net1_2 5.3093
RRg63 net1_2 net1_3 7.8014
RRg33 net9 net9_2 31.272
RRg51 net12 net12_2 31.1684
RRh36 CLK_2 CLK_3 15.1699
RRh35 CLK_1 CLK_2 18.1314
RRh37 CLK_2 CLK_4 17.9905
RRh7 D_1 D_2 11.3175
RRh8 D_2 D_3 20.4615
RRh25 RESET_B_7 RESET_B_8 112.788
RRh45 RESET_B_10 RESET_B_11 64.6196
RRh26 RESET_B_8 RESET_B_9 56.4598
RRh46 RESET_B_11 RESET_B_12 52.7375
RRh22 RESET_B_4 RESET_B_5 165.521
RRh24 RESET_B_6 RESET_B_7 38.721
RRh23 RESET_B_5 RESET_B_6 34.9624
RRh27 RESET_B_3 RESET_B_6 15
RRh9 SCD_3 SCD_4 35.2604
RRh6 SCD_1 SCD_2 24.2086
RRh4 SCE_3 SCE_5 17.2308
RRh5 SCE_3 SCE_6 13.4615
RRh3 SCE_2 SCE_4 20.9678
RRh1 SCE_1 SCE_2 16.6601
RRh2 SCE_2 SCE_3 9.1417
RRh11 SCEb_2 SCEb_3 15.6787
RRh10 SCEb SCEb_2 14.8139
RRh13 Db_4 Db_6 14.6018
RRh12 Db_5 Db_4 15.8908
RRh16 net13_6 net13_7 33.1615
RRh14 net13_5 net13_6 28.3153
RRh15 net13_6 net13_4 1.7627
RRh21 net4_2 net4_3 36.6702
RRh20 net4 net4_2 37.889
RRh17 net6 net6_2 15.4014
RRh18 net6_2 net6_3 16.0783
RRh19 net6_2 net6_4 15.5961
RRh33 clkneg_3 clkneg_4 137.092
RRh34 clkneg_4 clkneg_5 38.9296
RRh32 clkneg_2 clkneg_3 14.4487
RRh31 clkneg clkneg_2 13.5699
RRh40 clkneg_12 clkneg_13 30.3206
RRh38 clkneg_11 clkneg_12 16.3913
RRh39 clkneg_12 clkneg_6 20.0382
RRh42 clkpos_5 clkpos_10 7.7168
RRh41 clkpos_9 clkpos_5 30.889
RRh30 clkpos_2 clkpos_4 32.2576
RRh29 clkpos_2 clkpos_3 8.7038
RRh28 clkpos clkpos_2 49.9533
RRh51 net5 net5_9 24.0163
RRh55 net5 net5_13 27.5163
RRh52 net5_6 net5_10 21.809
RRh47 net5_5 net5_6 18.0398
RRh53 net5_7 net5_11 13.8287
RRh48 net5_6 net5_7 24.3299
RRh54 net5_8 net5_12 15.444
RRh50 net5_8 net5 23.2099
RRh49 net5_7 net5_8 26.9257
RRh43 net2 net2_2 36.0571
RRh44 net2_2 net2_3 11.7982
RRh58 net1_5 net1_6 18.3538
RRh56 net1_4 net1_5 20.5076
RRh57 net1_5 net1_2 26.2127
XP20 SCEb_4 SCE_6 VDD_10 VDD sg13_lv_pmos w=8.4e-07 l=1.3e-07  ng=1 ad=2.856e-13 as=2.53e-13 pd=2.36e-06 ps=1.53e-06 m=1
XP22 net64 SCE_1 VDD_10 VDD sg13_lv_pmos w=1e-06 l=1.3e-07 ng=1  ad=3.325e-13 as=2.53e-13 pd=1.665e-06 ps=1.53e-06 m=1
XP17 Db D_3 net64 VDD sg13_lv_pmos w=1e-06 l=1.3e-07 ng=1  ad=2.225e-13 as=3.325e-13 pd=1.445e-06 ps=1.665e-06 m=1
XP18 Db SCD_3 net62 VDD sg13_lv_pmos w=1e-06 l=1.3e-07 ng=1  ad=2.225e-13 as=2.975e-13 pd=1.445e-06 ps=1.595e-06 m=1
XP21 net62 SCEb VDD_17 VDD sg13_lv_pmos w=1e-06 l=1.3e-07 ng=1  ad=2.975e-13 as=2.198e-13 pd=1.595e-06 ps=1.52e-06 m=1
XP11 net4_8 net6_3 VDD_14 VDD sg13_lv_pmos w=1e-06 l=1.3e-07  ng=1 ad=3.4e-13 as=3.62387e-13 pd=2.68e-06 ps=2.605e-06 m=1
XP12 net4_4 clkneg_11 net5_4 VDD sg13_lv_pmos w=1e-06  l=1.3e-07 ng=1 ad=3.4e-13 as=1.9115e-13 pd=2.68e-06 ps=1.565e-06  m=1
XP5 net1 net5_5 VDD_11 VDD sg13_lv_pmos w=1e-06 l=1.3e-07 ng=1  ad=3.4e-13 as=3.718e-13 pd=2.68e-06 ps=2.92e-06 m=1
XP23 net13 Db_5 VDD_17 VDD sg13_lv_pmos w=1.12e-06 l=1.3e-07  ng=1 ad=6.048e-13 as=2.198e-13 pd=3.32e-06 ps=1.52e-06 m=1
XP3 clkpos_6 clkneg VDD_3 VDD sg13_lv_pmos w=1.12e-06 l=1.3e-07  ng=1 ad=3.864e-13 as=4.31025e-13 pd=2.93e-06 ps=2.145e-06 m=1
XP2 clkneg_7 CLK_1 VDD_3 VDD sg13_lv_pmos w=1.12e-06  l=1.3e-07 ng=1 ad=3.808e-13 as=4.31025e-13 pd=2.92e-06  ps=2.145e-06 m=1
XP6 Q_N_3 net5_12 VDD_12 VDD sg13_lv_pmos w=1.12e-06  l=1.3e-07 ng=1 ad=3.808e-13 as=2.014e-13 pd=2.92e-06 ps=1.53e-06  m=1
XP4 Q_1 net1_4 VDD_1 VDD sg13_lv_pmos w=1.12e-06 l=1.3e-07  ng=1 ad=3.808e-13 as=3.808e-13 pd=2.92e-06 ps=2.92e-06 m=1
XP1 Dbb net13_5 VDD_16 VDD sg13_lv_pmos w=4.2e-07 l=1.3e-07  ng=1 ad=7.98e-14 as=1.428e-13 pd=8e-07 ps=1.52e-06 m=1
XP0 Dbb RESET_B_9 VDD_14 VDD sg13_lv_pmos w=4.2e-07 l=1.3e-07  ng=1 ad=7.98e-14 as=3.62387e-13 pd=8e-07 ps=2.605e-06 m=1
XP10 net6_9 RESET_B_5 VDD_13 VDD sg13_lv_pmos w=4.2e-07  l=1.3e-07 ng=1 ad=1.47e-13 as=1.563e-13 pd=1.54e-06 ps=1.22e-06  m=1
XP8 net7 net4 VDD_13 VDD sg13_lv_pmos w=4.2e-07 l=1.3e-07 ng=1  ad=5.46e-14 as=1.563e-13 pd=6.8e-07 ps=1.22e-06 m=1
XP9 net6_5 clkneg_5 net7 VDD sg13_lv_pmos w=4.2e-07 l=1.3e-07  ng=1 ad=7.98e-14 as=5.46e-14 pd=8e-07 ps=6.8e-07 m=1
XP7 Dbb_4 clkpos_3 net6_5 VDD sg13_lv_pmos w=4.2e-07 l=1.3e-07  ng=1 ad=1.428e-13 as=7.98e-14 pd=1.52e-06 ps=8e-07 m=1
XP14 net5_4 clkpos_9 net3 VDD sg13_lv_pmos w=4.2e-07 l=1.3e-07  ng=1 ad=1.9115e-13 as=5.25e-14 pd=1.565e-06 ps=6.7e-07 m=1
XP13 net3 net2_3 VDD_3 VDD sg13_lv_pmos w=4.2e-07 l=1.3e-07  ng=1 ad=5.25e-14 as=2.5605e-13 pd=6.7e-07 ps=1.935e-06 m=1
XP16 net2_6 RESET_B_11 VDD_3 VDD sg13_lv_pmos w=4.2e-07  l=1.3e-07 ng=1 ad=7.98e-14 as=2.5605e-13 pd=8e-07 ps=1.935e-06 m=1
XP15 net2_6 net5_13 VDD_12 VDD sg13_lv_pmos w=4.2e-07  l=1.3e-07 ng=1 ad=7.98e-14 as=2.014e-13 pd=8e-07 ps=1.53e-06 m=1
XN18 net63 SCE_4 VSS_11 VSS_3 sg13_lv_nmos w=7.4e-07  l=1.3e-07 ng=1 ad=1.3135e-13 as=1.8945e-13 pd=1.095e-06  ps=1.27e-06 m=1
XN22 Db_2 SCD_1 net63 VSS_3 sg13_lv_nmos w=7.4e-07 l=1.3e-07  ng=1 ad=1.628e-13 as=1.3135e-13 pd=1.18e-06 ps=1.095e-06 m=1
XN21 Db_2 D_1 net65 VSS_3 sg13_lv_nmos w=7.4e-07 l=1.3e-07  ng=1 ad=1.628e-13 as=3.367e-13 pd=1.18e-06 ps=1.65e-06 m=1
XN17 net65 SCEb_3 VSS_16 VSS_3 sg13_lv_nmos w=7.4e-07  l=1.3e-07 ng=1 ad=3.367e-13 as=1.48e-13 pd=1.65e-06 ps=1.14e-06  m=1
XN23 net13_3 Db_6 VSS_16 VSS_3 sg13_lv_nmos w=7.4e-07  l=1.3e-07 ng=1 ad=4.033e-13 as=1.48e-13 pd=2.57e-06 ps=1.14e-06  m=1
XN11 net4_10 net6 VSS_15 VSS_3 sg13_lv_nmos w=7.4e-07  l=1.3e-07 ng=1 ad=2.516e-13 as=1.626e-13 pd=2.16e-06 ps=1.415e-06  m=1
XN3 clkpos_8 clkneg_3 VSS_3 VSS_3 sg13_lv_nmos w=7.4e-07  l=1.3e-07 ng=1 ad=2.516e-13 as=4.3315e-13 pd=2.16e-06 ps=2.205e-06  m=1
XN2 clkneg_10 CLK_3 VSS_3 VSS_3 sg13_lv_nmos w=7.4e-07  l=1.3e-07 ng=1 ad=2.516e-13 as=4.3315e-13 pd=2.16e-06 ps=2.205e-06  m=1
XN12 net4_9 clkpos_10 net5_3 VSS_3 sg13_lv_nmos w=7.4e-07  l=1.3e-07 ng=1 ad=3.473e-13 as=1.2665e-13 pd=2.71e-06 ps=1.145e-06  m=1
XN6 Q_N_2 net5_11 VSS_12 VSS_3 sg13_lv_nmos w=7.4e-07  l=1.3e-07 ng=1 ad=3.034e-13 as=1.3435e-13 pd=2.3e-06 ps=1.12e-06  m=1
XN4 Q_2 net1_6 VSS_1 VSS_3 sg13_lv_nmos w=7.4e-07 l=1.3e-07  ng=1 ad=2.516e-13 as=2.516e-13 pd=2.16e-06 ps=2.16e-06 m=1
XN0 Dbb_3 net13_7 net10 VSS_3 sg13_lv_nmos w=4.2e-07 l=1.3e-07  ng=1 ad=1.428e-13 as=6.09e-14 pd=1.52e-06 ps=7.1e-07 m=1
XN1 net10 RESET_B_8 VSS_15 VSS_3 sg13_lv_nmos w=4.2e-07  l=1.3e-07 ng=1 ad=6.09e-14 as=1.626e-13 pd=7.1e-07 ps=1.415e-06  m=1
XN10 net8 RESET_B_7 VSS_14 VSS_3 sg13_lv_nmos w=4.2e-07  l=1.3e-07 ng=1 ad=3.885e-14 as=1.701e-13 pd=6.05e-07 ps=1.65e-06  m=1
XN9 net9_2 net4_3 net8 VSS_3 sg13_lv_nmos w=4.2e-07 l=1.3e-07  ng=1 ad=1.596e-13 as=3.885e-14 pd=1.6e-06 ps=6.05e-07 m=1
XN7 Dbb_6 clkneg_4 net6_8 VSS_3 sg13_lv_nmos w=4.2e-07  l=1.3e-07 ng=1 ad=1.296e-13 as=8.1e-14 pd=1.52e-06 ps=8.1e-07 m=1
XN8 net6_8 clkpos_4 net9 VSS_3 sg13_lv_nmos w=4.2e-07  l=1.3e-07 ng=1 ad=8.1e-14 as=2.163e-13 pd=8.1e-07 ps=1.87e-06 m=1
XN14 net5_3 clkneg_13 net12_2 VSS_3 sg13_lv_nmos w=4.2e-07  l=1.3e-07 ng=1 ad=1.2665e-13 as=1.428e-13 pd=1.145e-06 ps=1.52e-06  m=1
XN13 net12 net2 VSS_13 VSS_3 sg13_lv_nmos w=4.2e-07 l=1.3e-07  ng=1 ad=1.428e-13 as=7.98e-14 pd=1.52e-06 ps=8e-07 m=1
XN16 net11 RESET_B_10 VSS_13 VSS_3 sg13_lv_nmos w=4.2e-07  l=1.3e-07 ng=1 ad=3.78e-14 as=7.98e-14 pd=6e-07 ps=8e-07 m=1
XN15 net2_4 net5_9 net11 VSS_3 sg13_lv_nmos w=4.2e-07  l=1.3e-07 ng=1 ad=1.428e-13 as=3.78e-14 pd=1.52e-06 ps=6e-07 m=1
XN5 net1_3 net5_10 VSS_12 VSS_3 sg13_lv_nmos w=6.4e-07  l=1.3e-07 ng=1 ad=2.176e-13 as=1.3435e-13 pd=1.96e-06 ps=1.12e-06  m=1
.ends sg13g2_sdfrbp_1_flat

* Converted from Spectre av_extracted (sg13g2_stdcell_rc_HU_v2.scs)
* Cell: sg13g2_sdfrbp_2   Ports: Q Q_N CLK D RESET_B SCD SCE VDD VSS
