* NGSPICE file created from sg13g2_einvn_2_flat.ext - technology: ihp-sg13g2

.subckt sg13g2_einvn_2_flat Z A VSS TE_B VDD
X0 a_210_508# TE_B VSS VSS sg13_lv_nmos ad=0.1428p pd=1.52u as=0.1428p ps=1.52u w=0.42u l=0.13u
X1 a_210_508# TE_B VDD VDD sg13_lv_pmos ad=0.2176p pd=1.96u as=0.2176p ps=1.96u w=0.64u l=0.13u
X2 VSS a_210_508# a_324_114# VSS sg13_lv_nmos ad=0.1406p pd=1.12u as=0.2516p ps=2.16u w=0.74u l=0.13u
X3 a_324_114# a_210_508# VSS VSS sg13_lv_nmos ad=0.1406p pd=1.12u as=0.1406p ps=1.12u w=0.74u l=0.13u
X4 VDD TE_B a_322_412# VDD sg13_lv_pmos ad=0.2128p pd=1.5u as=0.3808p ps=2.92u w=1.12u l=0.13u
X5 a_322_412# TE_B VDD VDD sg13_lv_pmos ad=0.2128p pd=1.5u as=0.2128p ps=1.5u w=1.12u l=0.13u
X6 Z A a_324_114# VSS sg13_lv_nmos ad=0.1406p pd=1.12u as=0.1406p ps=1.12u w=0.74u l=0.13u
X7 Z A a_322_412# VDD sg13_lv_pmos ad=0.2128p pd=1.5u as=0.2128p ps=1.5u w=1.12u l=0.13u
X8 a_324_114# A Z VSS sg13_lv_nmos ad=0.2516p pd=2.16u as=0.1406p ps=1.12u w=0.74u l=0.13u
X9 a_322_412# A Z VDD sg13_lv_pmos ad=0.3808p pd=2.92u as=0.2128p ps=1.5u w=1.12u l=0.13u
C0 Z a_324_114# 0.13086f
C1 TE_B a_210_508# 0.24246f
C2 VDD Z 0.01344f
C3 a_322_412# TE_B 0.03734f
C4 a_322_412# a_210_508# 0.16357f
C5 a_210_508# a_324_114# 0.12603f
C6 a_322_412# a_324_114# 0.05933f
C7 VDD TE_B 0.37963f
C8 VDD a_210_508# 0.16928f
C9 a_322_412# VDD 0.564f
C10 Z A 0.182f
C11 TE_B A 0.01257f
C12 A a_210_508# 0.02015f
C13 a_322_412# A 0.05847f
C14 A a_324_114# 0.08544f
C15 Z a_210_508# 0.0165f
C16 a_322_412# Z 0.36254f
C17 VDD A 0.12215f
C18 Z VSS 0.01579f
C19 A VSS 0.5396f
C20 TE_B VSS 0.54717f
C21 VDD VSS 0.19609f
C22 a_324_114# VSS 0.38291f $ **FLOATING
C23 a_322_412# VSS 0.04143f $ **FLOATING
C24 a_210_508# VSS 0.43935f $ **FLOATING
.ends
