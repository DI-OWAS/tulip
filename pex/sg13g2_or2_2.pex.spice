* NGSPICE file created from sg13g2_or2_2_flat.ext - technology: ihp-sg13g2

.subckt sg13g2_or2_2_flat B VSS A X VDD
X0 X a_22_492# VDD VDD sg13_lv_pmos ad=0.252p pd=1.57u as=0.2226p ps=1.535u w=1.12u l=0.13u
X1 X a_22_492# VSS VSS sg13_lv_nmos ad=0.1665p pd=1.19u as=0.14642p ps=1.155u w=0.74u l=0.13u
X2 VSS A a_22_492# VSS sg13_lv_nmos ad=0.14642p pd=1.155u as=0.1045p ps=0.93u w=0.55u l=0.13u
X3 VDD A a_116_492# VDD sg13_lv_pmos ad=0.2226p pd=1.535u as=0.1596p ps=1.22u w=0.84u l=0.13u
X4 VDD a_22_492# X VDD sg13_lv_pmos ad=0.4256p pd=3u as=0.252p ps=1.57u w=1.12u l=0.13u
X5 a_116_492# B a_22_492# VDD sg13_lv_pmos ad=0.1596p pd=1.22u as=0.2856p ps=2.36u w=0.84u l=0.13u
X6 a_22_492# B VSS VSS sg13_lv_nmos ad=0.1045p pd=0.93u as=0.187p ps=1.78u w=0.55u l=0.13u
X7 VSS a_22_492# X VSS sg13_lv_nmos ad=0.2812p pd=2.24u as=0.1665p ps=1.19u w=0.74u l=0.13u
C0 A a_22_492# 0.19385f
C1 A B 0.12811f
C2 VDD a_22_492# 0.24881f
C3 X A 0.01858f
C4 VDD B 0.1562f
C5 X VDD 0.29062f
C6 B a_22_492# 0.12599f
C7 VDD a_116_492# 0.01298f
C8 VDD A 0.08726f
C9 X a_22_492# 0.1305f
C10 X VSS 0.2101f
C11 A VSS 0.20974f
C12 B VSS 0.24872f
C13 VDD VSS 0.1646f
C14 a_22_492# VSS 0.86395f $ **FLOATING
.ends
