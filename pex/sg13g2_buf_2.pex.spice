* NGSPICE file created from sg13g2_buf_2_flat.ext - technology: ihp-sg13g2

.subckt sg13g2_buf_2_flat VSS VDD X A
X0 a_21_304# A VSS VSS sg13_lv_nmos ad=0.2176p pd=1.96u as=0.1371p ps=1.12u w=0.64u l=0.13u
X1 a_21_304# A VDD VDD sg13_lv_pmos ad=0.34p pd=2.68u as=0.2086p ps=1.5u w=1u l=0.13u
X2 X a_21_304# VSS VSS sg13_lv_nmos ad=0.1406p pd=1.12u as=0.2516p ps=2.16u w=0.74u l=0.13u
X3 X a_21_304# VDD VDD sg13_lv_pmos ad=0.2128p pd=1.5u as=0.7336p ps=3.55u w=1.12u l=0.13u
X4 VSS a_21_304# X VSS sg13_lv_nmos ad=0.1371p pd=1.12u as=0.1406p ps=1.12u w=0.74u l=0.13u
X5 VDD a_21_304# X VDD sg13_lv_pmos ad=0.2086p pd=1.5u as=0.2128p ps=1.5u w=1.12u l=0.13u
C0 X VDD 0.01447f
C1 A a_21_304# 0.32652f
C2 A VDD 0.06778f
C3 VDD a_21_304# 0.53005f
C4 X a_21_304# 0.52645f
C5 A VSS 0.25716f
C6 X VSS 0.22069f
C7 VDD VSS 0.15245f
C8 a_21_304# VSS 0.81489f $ **FLOATING
.ends
