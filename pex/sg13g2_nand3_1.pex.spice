* NGSPICE file created from sg13g2_nand3_1_flat.ext - technology: ihp-sg13g2

.subckt sg13g2_nand3_1_flat VDD Y B C VSS A
X0 Y C VDD VDD sg13_lv_pmos ad=0.2128p pd=1.5u as=0.3808p ps=2.92u w=1.12u l=0.13u
X1 VDD B Y VDD sg13_lv_pmos ad=0.2128p pd=1.5u as=0.2128p ps=1.5u w=1.12u l=0.13u
X2 Y A VDD VDD sg13_lv_pmos ad=0.3808p pd=2.92u as=0.2128p ps=1.5u w=1.12u l=0.13u
X3 a_146_122# C VSS VSS sg13_lv_nmos ad=0.17205p pd=1.205u as=0.2886p ps=2.26u w=0.74u l=0.13u
X4 a_265_122# B a_146_122# VSS sg13_lv_nmos ad=0.10915p pd=1.035u as=0.17205p ps=1.205u w=0.74u l=0.13u
X5 Y A a_265_122# VSS sg13_lv_nmos ad=0.3293p pd=2.37u as=0.10915p ps=1.035u w=0.74u l=0.13u
C0 Y A 0.20023f
C1 C B 0.09614f
C2 VDD B 0.06419f
C3 Y VDD 0.5654f
C4 A VDD 0.07228f
C5 Y B 0.10102f
C6 C VDD 0.12267f
C7 A B 0.13001f
C8 Y VSS 0.18175f
C9 A VSS 0.26136f
C10 B VSS 0.23581f
C11 C VSS 0.29166f
C12 VDD VSS 0.15898f
C13 a_146_122# VSS 0.0107f $ **FLOATING
.ends
