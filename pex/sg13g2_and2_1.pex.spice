* NGSPICE file created from sg13g2_and2_1_flat.ext - technology: ihp-sg13g2

.subckt sg13g2_and2_1_flat X VSS VDD B A
X0 X a_45_160# VDD VDD sg13_lv_pmos ad=0.3808p pd=2.92u as=0.1918p ps=1.5u w=1.12u l=0.13u
X1 X a_45_160# VSS VSS sg13_lv_nmos ad=0.2516p pd=2.16u as=0.1331p ps=1.12u w=0.74u l=0.13u
X2 a_45_160# A VDD VDD sg13_lv_pmos ad=0.1596p pd=1.22u as=0.2856p ps=2.36u w=0.84u l=0.13u
X3 VDD B a_45_160# VDD sg13_lv_pmos ad=0.1918p pd=1.5u as=0.1596p ps=1.22u w=0.84u l=0.13u
X4 a_139_160# A a_45_160# VSS sg13_lv_nmos ad=0.1216p pd=1.02u as=0.2176p ps=1.96u w=0.64u l=0.13u
X5 VSS B a_139_160# VSS sg13_lv_nmos ad=0.1331p pd=1.12u as=0.1216p ps=1.02u w=0.64u l=0.13u
C0 X VDD 0.16011f
C1 a_45_160# B 0.25584f
C2 A VDD 0.07623f
C3 a_45_160# X 0.10507f
C4 A B 0.06131f
C5 VDD B 0.06875f
C6 A a_45_160# 0.10356f
C7 a_45_160# VDD 0.434f
C8 X VSS 0.18903f
C9 B VSS 0.20387f
C10 A VSS 0.48991f
C11 VDD VSS 0.14619f
C12 a_45_160# VSS 0.33271f $ **FLOATING
.ends
