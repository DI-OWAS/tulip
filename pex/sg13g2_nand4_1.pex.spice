* NGSPICE file created from sg13g2_nand4_1_flat.ext - technology: ihp-sg13g2

.subckt sg13g2_nand4_1_flat VDD Y B C VSS A D
X0 Y D VDD VDD sg13_lv_pmos ad=0.2128p pd=1.5u as=0.3808p ps=2.92u w=1.12u l=0.13u
X1 VDD C Y VDD sg13_lv_pmos ad=0.2128p pd=1.5u as=0.2128p ps=1.5u w=1.12u l=0.13u
X2 Y B VDD VDD sg13_lv_pmos ad=0.2128p pd=1.5u as=0.2128p ps=1.5u w=1.12u l=0.13u
X3 VDD A Y VDD sg13_lv_pmos ad=0.3808p pd=2.92u as=0.2128p ps=1.5u w=1.12u l=0.13u
X4 a_247_122# C a_146_122# VSS sg13_lv_nmos ad=0.14245p pd=1.125u as=0.13875p ps=1.115u w=0.74u l=0.13u
X5 a_146_122# D VSS VSS sg13_lv_nmos ad=0.13875p pd=1.115u as=0.2886p ps=2.26u w=0.74u l=0.13u
X6 a_350_122# B a_247_122# VSS sg13_lv_nmos ad=0.1406p pd=1.12u as=0.14245p ps=1.125u w=0.74u l=0.13u
X7 Y A a_350_122# VSS sg13_lv_nmos ad=0.2516p pd=2.16u as=0.1406p ps=1.12u w=0.74u l=0.13u
C0 B VDD 0.06233f
C1 B A 0.14522f
C2 VDD A 0.06956f
C3 Y C 0.09764f
C4 D VDD 0.12434f
C5 B C 0.14585f
C6 VDD C 0.06386f
C7 B Y 0.09035f
C8 VDD Y 0.68729f
C9 Y A 0.18534f
C10 D C 0.10371f
C11 Y VSS 0.14634f
C12 A VSS 0.2576f
C13 B VSS 0.2343f
C14 C VSS 0.23744f
C15 D VSS 0.30954f
C16 VDD VSS 0.19255f
C17 a_146_122# VSS 0.01247f $ **FLOATING
.ends
