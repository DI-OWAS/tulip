* Converted from Spectre av_extracted (sg13g2_stdcell_rc_HU_v2.scs)
* Cell: sg13g2_dfrbp_1   Ports: Q Q_N CLK D RESET_B VDD VSS
.subckt sg13g2_dlhr_1_flat Q Q_N D GATE RESET_B VDD VSS
XX4 Db_6 D_3 VSS_7 VSS_2 sg13_lv_nmos w=5.5e-07 l=1.3e-07  ng=1 ad=1.87e-13 as=1.5055e-13 pd=1.78e-06 ps=1.17e-06 m=1
XX22 qintn_b_3 qint_b_12 VSS_1 VSS_2 sg13_lv_nmos w=5.5e-07  l=1.3e-07 ng=1 ad=1.87e-13 as=1.491e-13 pd=1.78e-06 ps=1.18e-06  m=1
CC1 D VSS 5.62507e-18
CC2 GATE VSS 6.56237e-18
CC3 Q VSS 3.91666e-18
CC4 Q_N VSS 4.46907e-18
CC5 VDD VSS 1.36612e-16
CC6 Db VSS 6.57816e-17
CC7 GATE_B VSS 3.53135e-17
CC8 GATE_BB VSS 5.36388e-17
CC9 qint VSS 1.24239e-16
CC10 qint_b VSS 2.37422e-17
CC11 qintn_b VSS 8.99711e-17
CC12 qintn_b_6 VSS 2.69581e-17
CC13 qint_b_12 VSS 2.32214e-17
CC14 qint_b_11 VSS 2.609e-17
CC15 RESET_B_6 VSS 6.48651e-17
CC16 qint_5 VSS 6.04892e-17
CC17 qint_b_3 VSS 1.20023e-16
CC18 GATE_B_6 VSS 1.10509e-16
CC19 GATE_B_4 VSS 2.72596e-17
CC20 GATE_3 VSS 2.23847e-17
CC21 D_3 VSS 2.09628e-17
CC22 qintn_b_5 VSS 3.85088e-17
CC23 qint_b_9 VSS 3.89085e-17
CC24 qint_b_13 VSS 2.47339e-17
CC25 RESET_B_4 VSS 5.28265e-17
CC26 qint_7 VSS 5.29635e-17
CC27 GATE_BB_4 VSS 2.77288e-17
CC28 GATE_B_7 VSS 1.54169e-16
CC29 Db_3 VSS 7.55619e-17
CC30 GATE_1 VSS 2.06765e-17
CC31 D_1 VSS 1.33785e-17
CC32 qint_b_4 VSS 1.43072e-16
CC33 RESET_B_2 VSS 1.50637e-16
CC34 qint_b_2 VSS 1.81649e-16
CC35 GATE_BB_3 VSS 1.5026e-16
CC36 GATE_B_5 VSS 1.26721e-16
CC37 GATE_BB_2 VSS 1.34923e-16
CC38 Db_2 VSS 1.57888e-16
CC39 GATE_B_3 VSS 9.69695e-17
CC40 GATE_2 VSS 1.12194e-16
CC41 D_2 VSS 9.11092e-17
CC42 VDD_2 VSS 6.59062e-17
CC43 VDD_1 VSS 3.01945e-18
CC44 VDD_8 VSS 9.31093e-19
CC45 qint_b_7 VSS 3.15927e-19
CC46 VDD_9 VSS 5.52799e-18
CC47 qint_3 VSS 6.70817e-18
CC48 Q_N_3 VSS 9.54816e-18
CC49 qintn_b_3 VSS 1.5525e-18
CC50 Q_3 VSS 2.94848e-17
CC51 qint_b_8 VSS 1.31128e-17
CC52 qint_4 VSS 9.46153e-18
CC53 GATE_BB_6 VSS 3.02805e-17
CC54 GATE_B_9 VSS 3.06641e-17
CC55 GATE_BB_7 VSS 1.24508e-17
CC56 GATE_B_10 VSS 1.93041e-18
CC57 Db_6 VSS 2.60408e-17
CC58 Db_4 VSS 6.68379e-18
CC59 GATE_B_2 VSS 7.95843e-17
CC60 qint_2 VSS 2.04042e-17
CC61 qint_6 VSS 9.88271e-17
CC62 RESET_B_3 VSS 9.33554e-18
CC63 qint_b_6 VSS 2.28196e-17
CC64 qint_b_10 VSS 1.22206e-16
CC65 qintn_b_2 VSS 3.35531e-17
CC66 VDD_4 VSS 9.3849e-19
CC67 VDD_7 VSS 1.11167e-18
RRg1 D_4 D 0.004783
RRg2 D_5 D_6 0.004783
RRg3 D_4 D_6 0.02232
RRg4 D_2 D_5 15
RRg5 GATE GATE_4 0.02017
RRg6 GATE_2 GATE_4 15
RRg7 Db_2 Db_5 17.0694
RRg8 Db_5 Db_6 15.9346
RRg9 Db_4 Db_5 7.5
RRg10 GATE_B_5 GATE_B_8 1.4257
RRg11 GATE_B_8 GATE_B_9 7.5532
RRg12 GATE_B_8 GATE_B_3 0.3016
RRg13 GATE_B_3 GATE_B_10 15.3643
RRg14 GATE_BB_3 GATE_BB_2 1.8269
RRg15 GATE_BB_2 GATE_BB_5 0.6985
RRg16 GATE_BB_5 GATE_BB_6 15.0773
RRg17 GATE_BB_5 GATE_BB_7 15.5722
RRg18 qint qint_2 15.6684
RRg19 qint_2 qint_3 15.6632
RRg20 qint_2 qint_4 15.5567
RRg21 RESET_B_1 RESET_B_2 0.006
RRg22 RESET_B RESET_B_3 0.006
RRg23 RESET_B_1 RESET_B_3 0.02488
RRg24 qint_b_4 qint_b_5 15.6377
RRg25 qint_b_5 qint_b_6 0.09072
RRg26 qint_b_6 qint_b_2 15.2308
RRg27 qint_b_5 qint_b_7 5.1171
RRg28 qint_b_6 qint_b_8 8.2536
RRg29 Q_2 Q 0.008462
RRg30 Q Q_3 8.6202
RRg31 Q_1 Q_2 7.5
RRg32 qintn_b qintn_b_2 15.2202
RRg33 qintn_b_2 qintn_b_3 15.5738
RRg34 qintn_b_2 qintn_b_4 8.1541
RRg35 Q_N_2 Q_N 0.01128
RRg36 Q_N Q_N_3 8.3692
RRg37 Q_N_1 Q_N_2 5
RRg38 VDD_1 VDD_3 8.0794
RRg39 VDD_3 VDD_4 0.3114
RRg40 VDD_4 VDD_5 0.2899
RRg41 VDD_5 VDD 0.1161
RRg42 VDD VDD_6 0.3475
RRg43 VDD_6 VDD_7 0.08037
RRg44 VDD_7 VDD_2 15.685
RRg45 VDD_4 VDD_8 7.9454
RRg46 VDD_5 VDD_9 7.5973
RRg47 VDD_7 VDD_2 15.2268
RRg48 VDD_2 VDD_3 3
RRg49 VDD_2 VDD_6 1.1538
RRg50 VSS_1 VSS_3 7.8377
RRg51 VSS_3 VSS_4 0.3397
RRg52 VSS_4 VSS 0.336
RRg53 VSS VSS_5 0.3987
RRg54 VSS_5 VSS_6 0.08436
RRg55 VSS_6 VSS_7 8.2135
RRg56 VSS_4 VSS_8 7.7206
RRg57 VSS VSS_9 15.3381
RRg58 VSS_6 VSS_2 15.1285
RRg59 VSS_2 VSS_3 3
RRg60 VSS_2 VSS_5 1.1538
RRh1 D_1 D_2 13.8711
RRh2 D_2 D_3 13.4136
RRh3 GATE_1 GATE_2 18.8786
RRh4 GATE_2 GATE_3 18.3201
RRh5 GATE_B GATE_B_2 25.7536
RRh6 GATE_B_2 GATE_B_3 29.7947
RRh7 GATE_B_2 GATE_B_4 13.4017
RRh8 Db Db_2 23.4972
RRh9 Db_2 Db_3 16.6444
RRh10 GATE_BB GATE_BB_2 24.1059
RRh11 GATE_B_5 GATE_B_6 21.5163
RRh12 GATE_B_6 GATE_B_7 79.8226
RRh13 GATE_BB_3 GATE_BB_4 33.9923
RRh14 qint_b qint_b_2 19.8752
RRh15 qint_b_2 qint_b_3 49.3311
RRh16 qint_5 qint_6 22.1827
RRh17 qint_6 qint 7.4857
RRh18 qint_6 qint_7 24.3017
RRh19 RESET_B_4 RESET_B_5 24.601
RRh20 RESET_B_5 RESET_B_6 10.5531
RRh21 RESET_B_2 RESET_B_5 15
RRh22 qint_b_9 qint_b_10 42.7419
RRh23 qint_b_10 qint_b_4 36.3333
RRh24 qint_b_4 qint_b_11 16.1059
RRh25 qint_b_10 qint_b_12 27.9418
RRh26 qint_b_4 qint_b_13 16.6444
RRh27 qintn_b_5 qintn_b 18.2598
RRh28 qintn_b qintn_b_6 15.5675
XX13 Db_4 D_1 VDD_2 VDD sg13_lv_pmos w=8.4e-07 l=1.3e-07 ng=1  ad=2.856e-13 as=3.018e-13 pd=2.36e-06 ps=1.97e-06 m=1
XX5 GATE_B_10 GATE_1 VDD_2 VDD sg13_lv_pmos w=8.4e-07  l=1.3e-07 ng=1 ad=3.234e-13 as=3.018e-13 pd=2.45e-06 ps=1.97e-06  m=1
XX20 GATE_BB_7 GATE_B VDD_2 VDD sg13_lv_pmos w=8.4e-07  l=1.3e-07 ng=1 ad=2.856e-13 as=2.6675e-13 pd=2.36e-06 ps=1.845e-06  m=1
XX2 qintn_b_4 qint_b_9 VDD_1 VDD sg13_lv_pmos w=8.4e-07  l=1.3e-07 ng=1 ad=2.856e-13 as=1.974e-13 pd=2.36e-06 ps=1.5e-06  m=1
XX18 net2 Db_3 VDD_2 VDD sg13_lv_pmos w=1e-06 l=1.3e-07 ng=1  ad=1.05e-13 as=2.6675e-13 pd=1.21e-06 ps=1.845e-06 m=1
XX10 qint_3 GATE_B_7 net2 VDD sg13_lv_pmos w=1e-06 l=1.3e-07  ng=1 ad=1.91e-13 as=1.05e-13 pd=1.44e-06 ps=1.21e-06 m=1
XX15 qint_3 GATE_BB_4 net11 VDD sg13_lv_pmos w=4.2e-07 l=1.3e-07  ng=1 ad=1.91e-13 as=1.008e-13 pd=1.44e-06 ps=9e-07 m=1
XX6 net11 qint_b VDD_9 VDD sg13_lv_pmos w=4.2e-07 l=1.3e-07 ng=1  ad=1.008e-13 as=2.387e-13 pd=9e-07 ps=1.84e-06 m=1
XX1 qint_b_7 qint_7 VDD_9 VDD sg13_lv_pmos w=1.12e-06  l=1.3e-07 ng=1 ad=2.128e-13 as=2.387e-13 pd=1.5e-06 ps=1.84e-06  m=1
XX0 qint_b_7 RESET_B_4 VDD_8 VDD sg13_lv_pmos w=1.12e-06  l=1.3e-07 ng=1 ad=2.128e-13 as=2.128e-13 pd=1.5e-06 ps=1.5e-06 m=1
XX9 Q_1 qint_b_13 VDD_8 VDD sg13_lv_pmos w=1.12e-06 l=1.3e-07  ng=1 ad=3.808e-13 as=2.128e-13 pd=2.92e-06 ps=1.5e-06 m=1
XX3 Q_N_1 qintn_b_5 VDD_1 VDD sg13_lv_pmos w=1.12e-06  l=1.3e-07 ng=1 ad=3.808e-13 as=1.974e-13 pd=2.92e-06 ps=1.5e-06  m=1
XX19 GATE_B_9 GATE_3 VSS_7 VSS_2 sg13_lv_nmos w=7.4e-07  l=1.3e-07 ng=1 ad=2.516e-13 as=1.5055e-13 pd=2.16e-06 ps=1.17e-06  m=1
XX17 GATE_BB_6 GATE_B_4 VSS_2 VSS_2 sg13_lv_nmos w=7.4e-07  l=1.3e-07 ng=1 ad=2.775e-13 as=2.13425e-13 pd=2.23e-06 ps=1.62e-06  m=1
XX12 qint_b_8 qint_5 net9 VSS_2 sg13_lv_nmos w=7.4e-07  l=1.3e-07 ng=1 ad=2.516e-13 as=7.77e-14 pd=2.16e-06 ps=9.5e-07 m=1
XX21 net9 RESET_B_6 VSS_8 VSS_2 sg13_lv_nmos w=7.4e-07  l=1.3e-07 ng=1 ad=7.77e-14 as=1.406e-13 pd=9.5e-07 ps=1.12e-06 m=1
XX7 Q_3 qint_b_11 VSS_8 VSS_2 sg13_lv_nmos w=7.4e-07  l=1.3e-07 ng=1 ad=2.516e-13 as=1.406e-13 pd=2.16e-06 ps=1.12e-06  m=1
XX8 Q_N_3 qintn_b_6 VSS_1 VSS_2 sg13_lv_nmos w=7.4e-07  l=1.3e-07 ng=1 ad=2.516e-13 as=1.491e-13 pd=2.16e-06 ps=1.18e-06  m=1
XX23 net1 Db VSS_2 VSS_2 sg13_lv_nmos w=6.4e-07 l=1.3e-07 ng=1  ad=7.2e-14 as=2.13425e-13 pd=8.65e-07 ps=1.62e-06 m=1
XX16 qint_4 GATE_BB net1 VSS_2 sg13_lv_nmos w=6.4e-07 l=1.3e-07  ng=1 ad=1.41e-13 as=7.2e-14 pd=1.17e-06 ps=8.65e-07 m=1
XX11 qint_4 GATE_B_6 net7 VSS_2 sg13_lv_nmos w=4.2e-07  l=1.3e-07 ng=1 ad=1.41e-13 as=4.725e-14 pd=1.17e-06 ps=6.45e-07  m=1
XX14 net7 qint_b_3 VSS_9 VSS_2 sg13_lv_nmos w=4.2e-07  l=1.3e-07 ng=1 ad=4.725e-14 as=1.428e-13 pd=6.45e-07 ps=1.52e-06  m=1
.ends sg13g2_dlhr_1_flat

* Converted from Spectre av_extracted (sg13g2_stdcell_rc_HU_v2.scs)
* Cell: sg13g2_dlhrq_1   Ports: Q D GATE RESET_B VDD VSS
