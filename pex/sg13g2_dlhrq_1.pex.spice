* Converted from Spectre av_extracted (sg13g2_stdcell_rc_HU_v2.scs)
* Cell: sg13g2_dfrbp_1   Ports: Q Q_N CLK D RESET_B VDD VSS
.subckt sg13g2_dlhrq_1_flat Q D GATE RESET_B VDD VSS
XX4 Db_4 D_4 VSS_6 VSS_1 sg13_lv_nmos w=5.5e-07 l=1.3e-07  ng=1 ad=3.025e-13 as=1.4875e-13 pd=2.2e-06 ps=1.16e-06 m=1
CC1 GATE VSS 8.6746e-18
CC2 Q VSS 1.04539e-17
CC3 RESET_B VSS 8.12377e-18
CC4 VDD VSS 1.17856e-16
CC5 Db VSS 5.47938e-17
CC6 GATE_B VSS 3.18946e-17
CC7 GATE_BB VSS 4.83384e-17
CC8 qint VSS 2.09585e-16
CC9 qint_b VSS 1.70735e-17
CC10 qint_b_10 VSS 2.48315e-17
CC11 RESET_B_4 VSS 5.71187e-17
CC12 qint_5 VSS 5.86846e-17
CC13 qint_b_3 VSS 9.45486e-17
CC14 GATE_B_11 VSS 5.93971e-17
CC15 Db_3 VSS 6.32637e-17
CC16 GATE_2 VSS 3.08688e-17
CC17 D_4 VSS 2.98065e-17
CC18 qint_b_9 VSS 3.06365e-17
CC19 RESET_B_2 VSS 5.04315e-17
CC20 qint_7 VSS 5.07968e-17
CC21 GATE_BB_4 VSS 1.88345e-17
CC22 GATE_B_10 VSS 1.07601e-16
CC23 GATE_B_4 VSS 3.36062e-17
CC24 GATE_4 VSS 2.95855e-17
CC25 D_6 VSS 2.63416e-17
CC26 qint_b_4 VSS 1.11655e-16
CC27 RESET_B_1 VSS 1.48167e-16
CC28 qint_b_2 VSS 2.36365e-16
CC29 GATE_B_8 VSS 7.14046e-18
CC30 GATE_BB_3 VSS 1.32468e-16
CC31 GATE_BB_2 VSS 1.45339e-16
CC32 Db_2 VSS 1.57881e-16
CC33 GATE_B_3 VSS 8.76854e-17
CC34 GATE_1 VSS 1.17534e-16
CC35 D_2 VSS 7.43679e-17
CC36 VDD_1 VSS 4.99097e-19
CC37 VDD_7 VSS 2.44355e-18
CC38 qint_b_8 VSS 2.92757e-19
CC39 VDD_8 VSS 3.19518e-18
CC40 qint_4 VSS 4.33518e-18
CC41 VDD_9 VSS 5.70337e-19
CC42 GATE_BB_7 VSS 9.64352e-18
CC43 GATE_B_5 VSS 2.55726e-18
CC44 VDD_6 VSS 2.1154e-18
CC45 Db_6 VSS 2.02691e-17
CC46 Q_3 VSS 3.6686e-17
CC47 qint_3 VSS 9.91556e-18
CC48 GATE_BB_5 VSS 2.12518e-17
CC49 GATE_B_6 VSS 4.55858e-18
CC50 Db_4 VSS 7.77328e-17
CC51 D_3 VSS 7.25973e-19
CC52 D_5 VSS 9.16899e-17
CC53 GATE_B_2 VSS 9.12863e-17
CC54 GATE_B_9 VSS 2.18271e-16
CC55 qint_2 VSS 4.43602e-17
CC56 qint_b_5 VSS 1.85672e-17
CC57 qint_b_6 VSS 1.40728e-17
CC58 VDD_2 VSS 1.33068e-18
CC59 VDD_3 VSS 2.81848e-18
CC60 VDD_5 VSS 2.70197e-18
RRg1 D_1 D_2 0.006875
RRg2 D D_3 0.006875
RRg3 D_1 D_3 0.02933
RRg4 GATE GATE_1 0.02265
RRg5 Db_4 Db_5 15.8887
RRg6 Db_5 Db_6 7.6054
RRg7 Db_5 Db_2 16.8024
RRg8 GATE_BB_3 GATE_BB_2 1.8669
RRg9 GATE_BB_2 GATE_BB_6 0.7486
RRg10 GATE_BB_6 GATE_BB_7 15.6453
RRg11 GATE_BB_5 GATE_BB_6 15
RRg12 GATE_B_5 GATE_B_3 15.3036
RRg13 GATE_B_3 GATE_B_7 0.4542
RRg14 GATE_B_7 GATE_B_8 17.4065
RRg15 GATE_B_6 GATE_B_7 7.5
RRg16 qint qint_2 15.8404
RRg17 qint_2 qint_3 15.7176
RRg18 qint_2 qint_4 15.5451
RRg19 RESET_B_1 RESET_B 0.01719
RRg20 qint_b_4 qint_b_5 15.6939
RRg21 qint_b_5 qint_b_6 0.6716
RRg22 qint_b_6 qint_b_2 15.2609
RRg23 qint_b_5 qint_b_7 7.7666
RRg24 qint_b_6 qint_b_8 5.1033
RRg26 Q Q_3 16.0709
RRg27 Q_1 Q 5
RRg28 VDD_1 VDD_2 7.6468
RRg29 VDD_2 VDD_3 0.2774
RRg30 VDD_3 VDD 0.3481
RRg31 VDD VDD_4 0.1213
RRg32 VDD_4 VDD_5 0.09061
RRg33 VDD_5 VDD_6 15.7057
RRg34 VDD_2 VDD_7 5.5084
RRg35 VDD_3 VDD_8 15.2533
RRg36 VDD_5 VDD_9 15.2533
RRg37 VDD_1 VDD_4 1.1538
RRg38 VSS_1 VSS_2 7.6694
RRg39 VSS_2 VSS_3 0.35
RRg40 VSS_3 VSS 0.2694
RRg41 VSS VSS_4 0.1037
RRg42 VSS_4 VSS_5 0.094
RRg43 VSS_5 VSS_6 15.6646
RRg44 VSS_2 VSS_7 15.3147
RRg45 VSS_3 VSS_8 15.2681
RRg46 VSS_5 VSS_9 15.1921
RRg47 VSS_1 VSS_4 1.1538
RRh1 D_4 D_5 18.5084
RRh2 D_5 D_2 18.25
RRh3 D_5 D_6 29.8392
RRh4 GATE_2 GATE_3 22.151
RRh5 GATE_3 GATE_4 22.349
RRh6 GATE_1 GATE_3 15
RRh7 GATE_B GATE_B_2 26.2614
RRh8 GATE_B_2 GATE_B_3 33.6956
RRh9 GATE_B_2 GATE_B_4 23.6292
RRh10 Db Db_2 11.7982
RRh11 Db_2 Db_3 31.9906
RRh12 GATE_BB GATE_BB_2 28.1444
RRh13 GATE_BB_3 GATE_BB_4 29.369
RRh14 GATE_B_8 GATE_B_9 0.3796
RRh15 GATE_B_9 GATE_B_10 49.8584
RRh16 GATE_B_9 GATE_B_11 34.7769
RRh17 qint_b qint_b_2 11.8293
RRh18 qint_b_2 qint_b_3 72.9695
RRh19 qint_5 qint_6 28.6442
RRh20 qint_6 qint 4.1978
RRh21 qint_6 qint_7 19.4555
RRh22 RESET_B_2 RESET_B_3 20.788
RRh23 RESET_B_3 RESET_B_4 18.6225
RRh24 RESET_B_1 RESET_B_3 15
RRh25 qint_b_9 qint_b_4 21.4039
RRh26 qint_b_4 qint_b_10 11.1693
XX13 Db_6 D_6 VDD_6 VDD sg13_lv_pmos w=8.4e-07 l=1.3e-07 ng=1  ad=2.856e-13 as=1.596e-13 pd=2.36e-06 ps=1.22e-06 m=1
XX5 GATE_B_5 GATE_4 VDD_6 VDD sg13_lv_pmos w=8.4e-07  l=1.3e-07 ng=1 ad=4.68375e-13 as=1.596e-13 pd=3e-06 ps=1.22e-06  m=1
XX20 GATE_BB_7 GATE_B_4 VDD_9 VDD sg13_lv_pmos w=8.4e-07  l=1.3e-07 ng=1 ad=2.856e-13 as=2.015e-13 pd=2.36e-06 ps=1.415e-06  m=1
XX18 net60 Db VDD_9 VDD sg13_lv_pmos w=1e-06 l=1.3e-07 ng=1  ad=1.375e-13 as=2.015e-13 pd=1.275e-06 ps=1.415e-06 m=1
XX10 qint_4 GATE_B_10 net60 VDD sg13_lv_pmos w=1e-06 l=1.3e-07  ng=1 ad=1.897e-13 as=1.375e-13 pd=1.42e-06 ps=1.275e-06 m=1
XX1 qint_b_8 qint_7 VDD_8 VDD sg13_lv_pmos w=1e-06 l=1.3e-07  ng=1 ad=1.9e-13 as=2.0165e-13 pd=1.38e-06 ps=1.615e-06 m=1
XX0 qint_b_8 RESET_B_2 VDD_7 VDD sg13_lv_pmos w=1e-06  l=1.3e-07 ng=1 ad=1.9e-13 as=2.038e-13 pd=1.38e-06 ps=1.5e-06 m=1
XX15 qint_4 GATE_BB_4 net92 VDD sg13_lv_pmos w=4.2e-07 l=1.3e-07  ng=1 ad=1.897e-13 as=1.1025e-13 pd=1.42e-06 ps=9.45e-07 m=1
XX6 net92 qint_b VDD_8 VDD sg13_lv_pmos w=4.2e-07 l=1.3e-07 ng=1  ad=1.1025e-13 as=2.0165e-13 pd=9.45e-07 ps=1.615e-06 m=1
XX9 Q_1 qint_b_9 VDD_7 VDD sg13_lv_pmos w=1.12e-06 l=1.3e-07  ng=1 ad=4.368e-13 as=2.038e-13 pd=3.02e-06 ps=1.5e-06 m=1
XX19 GATE_B_6 GATE_2 VSS_6 VSS_1 sg13_lv_nmos w=7.4e-07  l=1.3e-07 ng=1 ad=2.516e-13 as=1.4875e-13 pd=2.16e-06 ps=1.16e-06  m=1
XX17 GATE_BB_5 GATE_B VSS_9 VSS_1 sg13_lv_nmos w=7.4e-07  l=1.3e-07 ng=1 ad=3.458e-13 as=1.393e-13 pd=2.7e-06 ps=1.155e-06  m=1
XX12 qint_b_7 qint_5 net116 VSS_1 sg13_lv_nmos w=7.4e-07  l=1.3e-07 ng=1 ad=2.516e-13 as=8.88e-14 pd=2.16e-06 ps=9.8e-07 m=1
XX21 net116 RESET_B_4 VSS_7 VSS_1 sg13_lv_nmos w=7.4e-07  l=1.3e-07 ng=1 ad=8.88e-14 as=1.406e-13 pd=9.8e-07 ps=1.12e-06 m=1
XX7 Q_3 qint_b_10 VSS_7 VSS_1 sg13_lv_nmos w=7.4e-07  l=1.3e-07 ng=1 ad=2.516e-13 as=1.406e-13 pd=2.16e-06 ps=1.12e-06  m=1
XX23 net61 Db_3 VSS_9 VSS_1 sg13_lv_nmos w=6.4e-07 l=1.3e-07  ng=1 ad=8.32e-14 as=1.393e-13 pd=9e-07 ps=1.155e-06 m=1
XX16 qint_3 GATE_BB net61 VSS_1 sg13_lv_nmos w=6.4e-07 l=1.3e-07  ng=1 ad=1.5175e-13 as=8.32e-14 pd=1.14e-06 ps=9e-07 m=1
XX11 qint_3 GATE_B_11 net89 VSS_1 sg13_lv_nmos w=4.2e-07  l=1.3e-07 ng=1 ad=1.5175e-13 as=4.725e-14 pd=1.14e-06 ps=6.45e-07  m=1
XX14 net89 qint_b_3 VSS_8 VSS_1 sg13_lv_nmos w=4.2e-07  l=1.3e-07 ng=1 ad=4.725e-14 as=1.428e-13 pd=6.45e-07 ps=1.52e-06  m=1
.ends sg13g2_dlhrq_1_flat

* Converted from Spectre av_extracted (sg13g2_stdcell_rc_HU_v2.scs)
* Cell: sg13g2_dllr_1   Ports: Q Q_N D GATE_N RESET_B VDD VSS
