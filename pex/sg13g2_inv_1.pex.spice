* NGSPICE file created from sg13g2_inv_1_flat.ext - technology: ihp-sg13g2

.subckt sg13g2_inv_1_flat Y A VSS VDD
X0 Y A VSS VSS sg13_lv_nmos ad=0.259p pd=2.18u as=0.259p ps=2.18u w=0.74u l=0.13u
X1 Y A VDD VDD sg13_lv_pmos ad=0.392p pd=2.94u as=0.392p ps=2.94u w=1.12u l=0.13u
C0 Y VDD 0.1735f
C1 A VDD 0.17341f
C2 Y A 0.09621f
C3 Y VSS 0.23107f
C4 A VSS 0.41137f
C5 VDD VSS 0.12906f
.ends
