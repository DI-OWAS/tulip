* NGSPICE file created from sg13g2_a21o_2_flat.ext - technology: ihp-sg13g2

.subckt sg13g2_a21o_2_flat B1 X VDD VSS A1 A2
X0 a_453_436# B1 a_119_104# VDD sg13_lv_pmos ad=0.2125p pd=1.425u as=0.35p ps=2.7u w=1u l=0.13u
X1 X a_119_104# VSS VSS sg13_lv_nmos ad=0.1406p pd=1.12u as=0.2516p ps=2.16u w=0.74u l=0.13u
X2 VSS a_119_104# X VSS sg13_lv_nmos ad=0.2516p pd=2.16u as=0.1406p ps=1.12u w=0.74u l=0.13u
X3 VSS A2 a_589_140# VSS sg13_lv_nmos ad=0.2516p pd=2.16u as=94.35f ps=0.995u w=0.74u l=0.13u
X4 X a_119_104# VDD VDD sg13_lv_pmos ad=0.2128p pd=1.5u as=0.3808p ps=2.92u w=1.12u l=0.13u
X5 VDD a_119_104# X VDD sg13_lv_pmos ad=0.3808p pd=2.92u as=0.2128p ps=1.5u w=1.12u l=0.13u
X6 a_119_104# B1 VSS VSS sg13_lv_nmos ad=0.1406p pd=1.12u as=0.3811p ps=2.51u w=0.74u l=0.13u
X7 a_589_140# A1 a_119_104# VSS sg13_lv_nmos ad=94.35f pd=0.995u as=0.1406p ps=1.12u w=0.74u l=0.13u
X8 VDD A1 a_453_436# VDD sg13_lv_pmos ad=0.19p pd=1.38u as=0.2125p ps=1.425u w=1u l=0.13u
X9 a_453_436# A2 VDD VDD sg13_lv_pmos ad=0.34p pd=2.68u as=0.19p ps=1.38u w=1u l=0.13u
C0 B1 a_453_436# 0.03669f
C1 a_119_104# VDD 0.38432f
C2 VDD a_453_436# 0.29211f
C3 A2 VDD 0.07149f
C4 a_119_104# a_453_436# 0.13742f
C5 A2 a_453_436# 0.09526f
C6 B1 A1 0.12514f
C7 VDD A1 0.06378f
C8 a_119_104# A1 0.01932f
C9 VDD X 0.32524f
C10 a_119_104# X 0.12579f
C11 A1 a_453_436# 0.07222f
C12 A2 A1 0.15266f
C13 B1 VDD 0.07169f
C14 a_119_104# B1 0.18971f
C15 A2 VSS 0.31957f
C16 A1 VSS 0.21955f
C17 B1 VSS 0.22238f
C18 X VSS 0.23756f
C19 VDD VSS 0.21094f
C20 a_453_436# VSS 0.03455f $ **FLOATING
C21 a_119_104# VSS 0.75147f $ **FLOATING
.ends
