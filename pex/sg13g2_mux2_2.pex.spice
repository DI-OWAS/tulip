* NGSPICE file created from sg13g2_mux2_2_flat.ext - technology: ihp-sg13g2

.subckt sg13g2_mux2_2_flat A1 X S VDD VSS A0
X0 a_559_412# A1 a_382_118# VDD sg13_lv_pmos ad=0.2975p pd=1.595u as=0.2225p ps=1.445u w=1u l=0.13u
X1 VDD S a_59_156# VDD sg13_lv_pmos ad=0.253p pd=1.53u as=0.2856p ps=2.36u w=0.84u l=0.13u
X2 VSS S a_59_156# VSS sg13_lv_nmos ad=0.18945p pd=1.27u as=0.187p ps=1.78u w=0.55u l=0.13u
X3 X a_382_118# VSS VSS sg13_lv_nmos ad=0.2035p pd=1.29u as=0.148p ps=1.14u w=0.74u l=0.13u
X4 X a_382_118# VDD VDD sg13_lv_pmos ad=0.308p pd=1.67u as=0.2198p ps=1.52u w=1.12u l=0.13u
X5 a_285_118# S VSS VSS sg13_lv_nmos ad=0.13135p pd=1.095u as=0.18945p ps=1.27u w=0.74u l=0.13u
X6 a_285_412# S VDD VDD sg13_lv_pmos ad=0.3325p pd=1.665u as=0.253p ps=1.53u w=1u l=0.13u
X7 VSS a_382_118# X VSS sg13_lv_nmos ad=0.3145p pd=2.33u as=0.2035p ps=1.29u w=0.74u l=0.13u
X8 VDD a_382_118# X VDD sg13_lv_pmos ad=0.476p pd=3.09u as=0.308p ps=1.67u w=1.12u l=0.13u
X9 VSS a_59_156# a_496_118# VSS sg13_lv_nmos ad=0.148p pd=1.14u as=0.3367p ps=1.65u w=0.74u l=0.13u
X10 VDD a_59_156# a_559_412# VDD sg13_lv_pmos ad=0.2198p pd=1.52u as=0.2975p ps=1.595u w=1u l=0.13u
X11 a_382_118# A1 a_285_118# VSS sg13_lv_nmos ad=0.1628p pd=1.18u as=0.13135p ps=1.095u w=0.74u l=0.13u
X12 a_496_118# A0 a_382_118# VSS sg13_lv_nmos ad=0.3367p pd=1.65u as=0.1628p ps=1.18u w=0.74u l=0.13u
X13 a_382_118# A0 a_285_412# VDD sg13_lv_pmos ad=0.2225p pd=1.445u as=0.3325p ps=1.665u w=1u l=0.13u
C0 A0 a_382_118# 0.11115f
C1 VDD a_59_156# 0.86952f
C2 a_382_118# A1 0.50836f
C3 VDD a_382_118# 0.16133f
C4 VDD X 0.39354f
C5 a_285_412# a_59_156# 0.03361f
C6 A0 A1 0.28551f
C7 a_382_118# a_285_412# 0.02399f
C8 A0 VDD 0.05439f
C9 a_559_412# a_59_156# 0.03338f
C10 S a_59_156# 0.13396f
C11 VDD A1 0.06517f
C12 a_382_118# a_559_412# 0.01147f
C13 S a_382_118# 0.11513f
C14 a_382_118# a_496_118# 0.03133f
C15 a_382_118# a_59_156# 0.39419f
C16 S A1 0.03201f
C17 a_382_118# a_285_118# 0.0165f
C18 S VDD 0.12839f
C19 a_382_118# X 0.22001f
C20 a_496_118# A1 0.01573f
C21 A0 a_59_156# 0.01594f
C22 A1 a_59_156# 0.07974f
C23 X VSS 0.25047f
C24 A1 VSS 0.25845f
C25 A0 VSS 0.22344f
C26 S VSS 0.50044f
C27 VDD VSS 0.27359f
C28 a_382_118# VSS 0.99072f $ **FLOATING
C29 a_59_156# VSS 0.38347f $ **FLOATING
.ends
