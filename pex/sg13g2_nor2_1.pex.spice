* NGSPICE file created from sg13g2_nor2_1_flat.ext - technology: ihp-sg13g2

.subckt sg13g2_nor2_1_flat A VDD Y VSS B
X0 Y A VSS VSS sg13_lv_nmos ad=0.1406p pd=1.12u as=0.2516p ps=2.16u w=0.74u l=0.13u
X1 VSS B Y VSS sg13_lv_nmos ad=0.2516p pd=2.16u as=0.1406p ps=1.12u w=0.74u l=0.13u
X2 a_170_412# A VDD VDD sg13_lv_pmos ad=0.1176p pd=1.33u as=0.4032p ps=2.96u w=1.12u l=0.13u
X3 Y B a_170_412# VDD sg13_lv_pmos ad=0.3808p pd=2.92u as=0.1176p ps=1.33u w=1.12u l=0.13u
C0 B A 0.05647f
C1 VDD Y 0.13046f
C2 A VDD 0.12314f
C3 A Y 0.11667f
C4 B VDD 0.07013f
C5 B Y 0.19029f
C6 a_170_412# Y 0.01266f
C7 Y VSS 0.29652f
C8 B VSS 0.31298f
C9 A VSS 0.3363f
C10 VDD VSS 0.1501f
.ends
