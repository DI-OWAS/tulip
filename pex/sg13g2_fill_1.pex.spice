* NGSPICE file created from sg13g2_fill_1_flat.ext - technology: ihp-sg13g2

.subckt sg13g2_fill_1_flat VDD VSS
C0 VDD a_32_246# 0.05646f
C1 VDD VSS 0.05686f
C2 a_32_246# VSS 0.11886f
.ends
