* NGSPICE file created from sg13g2_inv_2_flat.ext - technology: ihp-sg13g2

.subckt sg13g2_inv_2_flat VSS VDD Y A
X0 Y A VDD VDD sg13_lv_pmos ad=0.2156p pd=1.505u as=0.3808p ps=2.92u w=1.12u l=0.13u
X1 VDD A Y VDD sg13_lv_pmos ad=0.3808p pd=2.92u as=0.2156p ps=1.505u w=1.12u l=0.13u
X2 Y A VSS VSS sg13_lv_nmos ad=0.1406p pd=1.12u as=0.2516p ps=2.16u w=0.74u l=0.13u
X3 VSS A Y VSS sg13_lv_nmos ad=0.2553p pd=2.17u as=0.1406p ps=1.12u w=0.74u l=0.13u
C0 VDD A 0.21534f
C1 VDD Y 0.2865f
C2 Y A 0.14593f
C3 Y VSS 0.23905f
C4 A VSS 0.60981f
C5 VDD VSS 0.1927f
.ends
