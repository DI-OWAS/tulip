* NGSPICE file created from sg13g2_and4_2_flat.ext - technology: ihp-sg13g2

.subckt sg13g2_and4_2_flat X B A VDD VSS C D
X0 VDD D a_135_118# VDD sg13_lv_pmos ad=0.2044p pd=1.53u as=0.1848p ps=1.28u w=0.84u l=0.13u
X1 a_385_118# C a_307_118# VSS sg13_lv_nmos ad=0.1408p pd=1.08u as=83.2f ps=0.9u w=0.64u l=0.13u
X2 a_307_118# B a_229_118# VSS sg13_lv_nmos ad=83.2f pd=0.9u as=83.2f ps=0.9u w=0.64u l=0.13u
X3 VSS D a_385_118# VSS sg13_lv_nmos ad=0.1351p pd=1.12u as=0.1408p ps=1.08u w=0.64u l=0.13u
X4 X a_135_118# VSS VSS sg13_lv_nmos ad=0.1924p pd=1.26u as=0.1351p ps=1.12u w=0.74u l=0.13u
X5 X a_135_118# VDD VDD sg13_lv_pmos ad=0.2912p pd=1.64u as=0.2044p ps=1.53u w=1.12u l=0.13u
X6 VSS a_135_118# X VSS sg13_lv_nmos ad=0.3626p pd=2.46u as=0.1924p ps=1.26u w=0.74u l=0.13u
X7 a_135_118# A VDD VDD sg13_lv_pmos ad=0.1596p pd=1.22u as=0.2856p ps=2.36u w=0.84u l=0.13u
X8 VDD B a_135_118# VDD sg13_lv_pmos ad=0.1596p pd=1.22u as=0.1596p ps=1.22u w=0.84u l=0.13u
X9 VDD a_135_118# X VDD sg13_lv_pmos ad=0.5488p pd=3.22u as=0.2912p ps=1.64u w=1.12u l=0.13u
X10 a_135_118# C VDD VDD sg13_lv_pmos ad=0.1848p pd=1.28u as=0.1596p ps=1.22u w=0.84u l=0.13u
X11 a_229_118# A a_135_118# VSS sg13_lv_nmos ad=83.2f pd=0.9u as=0.2176p ps=1.96u w=0.64u l=0.13u
C0 D a_135_118# 0.21103f
C1 VDD D 0.07027f
C2 A a_135_118# 0.30673f
C3 X a_135_118# 0.18174f
C4 A VDD 0.08476f
C5 X VDD 0.32849f
C6 VDD a_135_118# 0.74799f
C7 C D 0.15943f
C8 A B 0.21305f
C9 B a_135_118# 0.15739f
C10 C a_135_118# 0.08056f
C11 VDD B 0.07206f
C12 C VDD 0.07261f
C13 C a_385_118# 0.01152f
C14 C B 0.28513f
C15 X VSS 0.27716f
C16 D VSS 0.22048f
C17 C VSS 0.27283f
C18 B VSS 0.22005f
C19 A VSS 0.24535f
C20 VDD VSS 0.24388f
C21 a_135_118# VSS 0.65902f $ **FLOATING
.ends
