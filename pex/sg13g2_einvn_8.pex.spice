* NGSPICE file created from sg13g2_einvn_8_flat.ext - technology: ihp-sg13g2

.subckt sg13g2_einvn_8_flat A Z TE_B VDD VSS
X0 VSS a_160_412# a_332_123# VSS sg13_lv_nmos ad=0.1406p pd=1.12u as=0.1406p ps=1.12u w=0.74u l=0.13u
X1 VDD TE_B a_278_412# VDD sg13_lv_pmos ad=0.2156p pd=1.505u as=0.3808p ps=2.92u w=1.12u l=0.13u
X2 a_332_123# a_160_412# VSS VSS sg13_lv_nmos ad=0.1406p pd=1.12u as=0.1406p ps=1.12u w=0.74u l=0.13u
X3 Z A a_332_123# VSS sg13_lv_nmos ad=0.1406p pd=1.12u as=0.1406p ps=1.12u w=0.74u l=0.13u
X4 Z A a_278_412# VDD sg13_lv_pmos ad=0.2128p pd=1.5u as=0.3612p ps=1.765u w=1.12u l=0.13u
X5 a_332_123# A Z VSS sg13_lv_nmos ad=0.1406p pd=1.12u as=0.1406p ps=1.12u w=0.74u l=0.13u
X6 Z A a_332_123# VSS sg13_lv_nmos ad=0.1406p pd=1.12u as=0.1406p ps=1.12u w=0.74u l=0.13u
X7 a_278_412# TE_B VDD VDD sg13_lv_pmos ad=0.2128p pd=1.5u as=0.2156p ps=1.505u w=1.12u l=0.13u
X8 a_278_412# A Z VDD sg13_lv_pmos ad=0.2128p pd=1.5u as=0.2128p ps=1.5u w=1.12u l=0.13u
X9 Z A a_278_412# VDD sg13_lv_pmos ad=0.2128p pd=1.5u as=0.2128p ps=1.5u w=1.12u l=0.13u
X10 a_332_123# A Z VSS sg13_lv_nmos ad=0.1406p pd=1.12u as=0.1406p ps=1.12u w=0.74u l=0.13u
X11 VDD TE_B a_278_412# VDD sg13_lv_pmos ad=0.2128p pd=1.5u as=0.2128p ps=1.5u w=1.12u l=0.13u
X12 a_278_412# A Z VDD sg13_lv_pmos ad=0.2128p pd=1.5u as=0.2128p ps=1.5u w=1.12u l=0.13u
X13 Z A a_332_123# VSS sg13_lv_nmos ad=0.1406p pd=1.12u as=0.1406p ps=1.12u w=0.74u l=0.13u
X14 a_278_412# TE_B VDD VDD sg13_lv_pmos ad=0.2128p pd=1.5u as=0.2128p ps=1.5u w=1.12u l=0.13u
X15 Z A a_278_412# VDD sg13_lv_pmos ad=0.2128p pd=1.5u as=0.2128p ps=1.5u w=1.12u l=0.13u
X16 a_332_123# A Z VSS sg13_lv_nmos ad=0.1406p pd=1.12u as=0.1406p ps=1.12u w=0.74u l=0.13u
X17 VDD TE_B a_278_412# VDD sg13_lv_pmos ad=0.2128p pd=1.5u as=0.2128p ps=1.5u w=1.12u l=0.13u
X18 Z A a_332_123# VSS sg13_lv_nmos ad=0.1406p pd=1.12u as=0.1406p ps=1.12u w=0.74u l=0.13u
X19 a_278_412# TE_B VDD VDD sg13_lv_pmos ad=0.2128p pd=1.5u as=0.2128p ps=1.5u w=1.12u l=0.13u
X20 a_278_412# A Z VDD sg13_lv_pmos ad=0.2128p pd=1.5u as=0.2128p ps=1.5u w=1.12u l=0.13u
X21 a_332_123# A Z VSS sg13_lv_nmos ad=0.2516p pd=2.16u as=0.1406p ps=1.12u w=0.74u l=0.13u
X22 VDD TE_B a_278_412# VDD sg13_lv_pmos ad=0.2128p pd=1.5u as=0.2128p ps=1.5u w=1.12u l=0.13u
X23 Z A a_278_412# VDD sg13_lv_pmos ad=0.2128p pd=1.5u as=0.2128p ps=1.5u w=1.12u l=0.13u
X24 a_278_412# A Z VDD sg13_lv_pmos ad=0.3808p pd=2.92u as=0.2128p ps=1.5u w=1.12u l=0.13u
X25 a_160_412# TE_B VDD VDD sg13_lv_pmos ad=0.3808p pd=2.92u as=0.3808p ps=2.92u w=1.12u l=0.13u
X26 a_160_412# TE_B VSS VSS sg13_lv_nmos ad=0.2516p pd=2.16u as=0.2516p ps=2.16u w=0.74u l=0.13u
X27 a_278_412# TE_B VDD VDD sg13_lv_pmos ad=0.3612p pd=1.765u as=0.2128p ps=1.5u w=1.12u l=0.13u
X28 VSS a_160_412# a_332_123# VSS sg13_lv_nmos ad=0.1406p pd=1.12u as=0.2516p ps=2.16u w=0.74u l=0.13u
X29 a_332_123# a_160_412# VSS VSS sg13_lv_nmos ad=0.1406p pd=1.12u as=0.1406p ps=1.12u w=0.74u l=0.13u
X30 VSS a_160_412# a_332_123# VSS sg13_lv_nmos ad=0.1406p pd=1.12u as=0.1406p ps=1.12u w=0.74u l=0.13u
X31 a_332_123# a_160_412# VSS VSS sg13_lv_nmos ad=0.1406p pd=1.12u as=0.1406p ps=1.12u w=0.74u l=0.13u
X32 VSS a_160_412# a_332_123# VSS sg13_lv_nmos ad=0.1406p pd=1.12u as=0.1406p ps=1.12u w=0.74u l=0.13u
X33 a_332_123# a_160_412# VSS VSS sg13_lv_nmos ad=0.1406p pd=1.12u as=0.1406p ps=1.12u w=0.74u l=0.13u
C0 TE_B a_278_412# 0.177f
C1 a_278_412# a_160_412# 0.16319f
C2 TE_B a_160_412# 0.43394f
C3 a_278_412# a_332_123# 0.58601f
C4 TE_B a_332_123# 0.03069f
C5 A Z 0.86053f
C6 a_332_123# a_160_412# 0.34155f
C7 A VDD 0.44885f
C8 Z a_278_412# 0.79641f
C9 VDD a_278_412# 1.96207f
C10 TE_B VDD 0.69193f
C11 Z a_332_123# 0.62608f
C12 VDD a_160_412# 0.20939f
C13 A a_278_412# 0.12231f
C14 A a_160_412# 0.0134f
C15 Z VDD 0.02171f
C16 A a_332_123# 0.10481f
C17 Z VSS 0.02423f
C18 A VSS 1.87972f
C19 TE_B VSS 1.25761f
C20 VDD VSS 0.39176f
C21 a_332_123# VSS 1.77124f $ **FLOATING
C22 a_278_412# VSS 0.04361f $ **FLOATING
C23 a_160_412# VSS 1.3425f $ **FLOATING
.ends
