* NGSPICE file created from sg13g2_buf_4_flat.ext - technology: ihp-sg13g2

.subckt sg13g2_buf_4_flat X VSS A VDD
X0 a_111_82# A VSS VSS sg13_lv_nmos ad=0.2664p pd=2.2u as=0.3034p ps=1.56u w=0.74u l=0.13u
X1 X a_111_82# VSS VSS sg13_lv_nmos ad=0.1406p pd=1.12u as=0.2516p ps=2.16u w=0.74u l=0.13u
X2 X a_111_82# VDD VDD sg13_lv_pmos ad=0.2128p pd=1.5u as=0.3808p ps=2.92u w=1.12u l=0.13u
X3 VSS a_111_82# X VSS sg13_lv_nmos ad=0.1406p pd=1.12u as=0.1406p ps=1.12u w=0.74u l=0.13u
X4 VDD a_111_82# X VDD sg13_lv_pmos ad=0.2128p pd=1.5u as=0.2128p ps=1.5u w=1.12u l=0.13u
X5 X a_111_82# VSS VSS sg13_lv_nmos ad=0.1406p pd=1.12u as=0.1406p ps=1.12u w=0.74u l=0.13u
X6 VSS a_111_82# X VSS sg13_lv_nmos ad=0.3034p pd=1.56u as=0.1406p ps=1.12u w=0.74u l=0.13u
X7 X a_111_82# VDD VDD sg13_lv_pmos ad=0.2128p pd=1.5u as=0.2128p ps=1.5u w=1.12u l=0.13u
X8 VDD a_111_82# X VDD sg13_lv_pmos ad=0.203p pd=1.5u as=0.2128p ps=1.5u w=1.12u l=0.13u
X9 a_111_82# A VDD VDD sg13_lv_pmos ad=0.1596p pd=1.22u as=0.203p ps=1.5u w=0.84u l=0.13u
X10 VDD A a_111_82# VDD sg13_lv_pmos ad=0.2856p pd=2.36u as=0.1596p ps=1.22u w=0.84u l=0.13u
C0 a_111_82# X 0.44318f
C1 A VDD 0.11266f
C2 A a_111_82# 0.29834f
C3 a_111_82# VDD 0.48667f
C4 X VDD 0.65354f
C5 A VSS 0.33159f
C6 X VSS 0.33762f
C7 VDD VSS 0.21911f
C8 a_111_82# VSS 1.22897f $ **FLOATING
.ends
