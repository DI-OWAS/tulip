* NGSPICE file created from sg13g2_sdfbbp_1_flat.ext - technology: ihp-sg13g2

.subckt sg13g2_sdfbbp_1_flat Q SCD SCE CLK VDD VSS SET_B RESET_B Q_N D
X0 a_2070_544# a_942_136# a_1962_460# VDD sg13_lv_pmos ad=64.05f pd=0.725u as=0.1575p ps=1.25u w=0.42u l=0.13u
X1 VDD a_2128_482# a_3023_114# VDD sg13_lv_pmos ad=0.1918p pd=1.5u as=0.2856p ps=2.36u w=0.84u l=0.13u
X2 a_260_504# SCE VDD VDD sg13_lv_pmos ad=0.1248p pd=1.03u as=0.1216p ps=1.02u w=0.64u l=0.13u
X3 VDD CLK a_698_136# VDD sg13_lv_pmos ad=0.2128p pd=1.5u as=0.3808p ps=2.92u w=1.12u l=0.13u
X4 a_1179_136# a_942_136# a_260_159# VDD sg13_lv_pmos ad=0.10785p pd=1.02u as=0.2176p ps=1.96u w=0.64u l=0.13u
X5 a_399_123# SCE VSS VSS sg13_lv_nmos ad=0.1428p pd=1.52u as=0.14175p ps=1.095u w=0.42u l=0.13u
X6 VSS a_2128_482# a_2148_114# VSS sg13_lv_nmos ad=0.1405p pd=1.15u as=79.8f ps=0.8u w=0.42u l=0.13u
X7 VSS a_2128_482# a_3023_114# VSS sg13_lv_nmos ad=0.15245p pd=1.17u as=0.187p ps=1.78u w=0.55u l=0.13u
X8 a_942_136# a_698_136# VDD VDD sg13_lv_pmos ad=0.3976p pd=2.95u as=0.2128p ps=1.5u w=1.12u l=0.13u
X9 a_1303_459# a_698_136# a_1179_136# VDD sg13_lv_pmos ad=37.8f pd=0.6u as=0.10785p ps=1.02u w=0.42u l=0.13u
X10 VSS CLK a_698_136# VSS sg13_lv_nmos ad=0.3144p pd=1.86u as=0.2516p ps=2.16u w=0.74u l=0.13u
X11 a_1339_271# SET_B VDD VDD sg13_lv_pmos ad=0.2856p pd=1.52u as=0.1977p ps=1.41u w=0.84u l=0.13u
X12 a_1505_165# SET_B VSS VSS sg13_lv_nmos ad=0.2008p pd=1.385u as=0.19065p ps=1.43u w=0.55u l=0.13u
X13 a_1964_159# a_1339_271# VSS VSS sg13_lv_nmos ad=49.5f pd=0.73u as=0.187p ps=1.78u w=0.55u l=0.13u
X14 a_2358_114# SET_B VSS VSS sg13_lv_nmos ad=0.1406p pd=1.12u as=0.1405p ps=1.15u w=0.74u l=0.13u
X15 Q a_3023_114# VSS VSS sg13_lv_nmos ad=0.2516p pd=2.16u as=0.15245p ps=1.17u w=0.74u l=0.13u
X16 VDD a_1339_271# a_1303_459# VDD sg13_lv_pmos ad=0.1977p pd=1.41u as=37.8f ps=0.6u w=0.42u l=0.13u
X17 a_2128_482# a_1962_460# a_2358_114# VSS sg13_lv_nmos ad=0.1406p pd=1.12u as=0.1406p ps=1.12u w=0.74u l=0.13u
X18 a_2358_114# a_1715_123# a_2128_482# VSS sg13_lv_nmos ad=0.2516p pd=2.16u as=0.1406p ps=1.12u w=0.74u l=0.13u
X19 a_399_123# SCE VDD VDD sg13_lv_pmos ad=0.2176p pd=1.96u as=0.2176p ps=1.96u w=0.64u l=0.13u
X20 a_2479_432# a_1962_460# a_2128_482# VDD sg13_lv_pmos ad=89.99999f pd=1.18u as=0.24p ps=1.48u w=1u l=0.13u
X21 a_158_159# SCD VSS VSS sg13_lv_nmos ad=79.8f pd=0.8u as=0.1428p ps=1.52u w=0.42u l=0.13u
X22 VDD a_1715_123# a_2479_432# VDD sg13_lv_pmos ad=0.34p pd=2.68u as=89.99999f ps=1.18u w=1u l=0.13u
X23 a_260_159# SCE a_158_159# VSS sg13_lv_nmos ad=79.8f pd=0.8u as=79.8f ps=0.8u w=0.42u l=0.13u
X24 VDD a_2128_482# a_2070_544# VDD sg13_lv_pmos ad=0.306p pd=2.01u as=64.05f ps=0.725u w=0.42u l=0.13u
X25 a_260_159# D a_260_504# VDD sg13_lv_pmos ad=0.1248p pd=1.03u as=0.1248p ps=1.03u w=0.64u l=0.13u
X26 Q_N a_2128_482# VSS VSS sg13_lv_nmos ad=0.2516p pd=2.16u as=0.1254p ps=1.12u w=0.74u l=0.13u
X27 a_362_159# D a_260_159# VSS sg13_lv_nmos ad=38.85f pd=0.605u as=79.8f ps=0.8u w=0.42u l=0.13u
X28 VSS a_399_123# a_362_159# VSS sg13_lv_nmos ad=0.14175p pd=1.095u as=38.85f ps=0.605u w=0.42u l=0.13u
X29 VDD RESET_B a_1715_123# VDD sg13_lv_pmos ad=0.2128p pd=1.53u as=0.2304p ps=2u w=0.64u l=0.13u
X30 a_1962_460# a_698_136# a_1853_419# VDD sg13_lv_pmos ad=0.1575p pd=1.25u as=0.1866p ps=1.46u w=0.84u l=0.13u
X31 Q a_3023_114# VDD VDD sg13_lv_pmos ad=0.3808p pd=2.92u as=0.1918p ps=1.5u w=1.12u l=0.13u
X32 Q_N a_2128_482# VDD VDD sg13_lv_pmos ad=0.3808p pd=2.92u as=0.2128p ps=1.53u w=1.12u l=0.13u
X33 a_1339_271# a_1179_136# a_1505_165# VSS sg13_lv_nmos ad=0.1045p pd=0.93u as=0.2008p ps=1.385u w=0.55u l=0.13u
X34 a_1179_136# a_698_136# a_260_159# VSS sg13_lv_nmos ad=79.8f pd=0.8u as=0.1428p ps=1.52u w=0.42u l=0.13u
X35 a_1505_165# a_1715_123# a_1339_271# VSS sg13_lv_nmos ad=0.283p pd=2.37u as=0.1045p ps=0.93u w=0.55u l=0.13u
X36 VSS a_1339_271# a_1281_136# VSS sg13_lv_nmos ad=0.19065p pd=1.43u as=74.59999f ps=0.865u w=0.42u l=0.13u
X37 a_942_136# a_698_136# VSS VSS sg13_lv_nmos ad=0.2516p pd=2.16u as=0.3144p ps=1.86u w=0.74u l=0.13u
X38 VDD a_1715_123# a_1667_419# VDD sg13_lv_pmos ad=0.1596p pd=1.22u as=0.1218p ps=1.13u w=0.84u l=0.13u
X39 a_1281_136# a_942_136# a_1179_136# VSS sg13_lv_nmos ad=74.59999f pd=0.865u as=79.8f ps=0.8u w=0.42u l=0.13u
X40 a_2128_482# SET_B VDD VDD sg13_lv_pmos ad=0.24p pd=1.48u as=0.306p ps=2.01u w=1u l=0.13u
X41 a_64_504# a_399_123# a_260_159# VDD sg13_lv_pmos ad=0.2176p pd=1.96u as=0.1248p ps=1.03u w=0.64u l=0.13u
X42 a_1853_419# a_1339_271# VDD VDD sg13_lv_pmos ad=0.1866p pd=1.46u as=0.1596p ps=1.22u w=0.84u l=0.13u
X43 a_1667_419# a_1179_136# a_1339_271# VDD sg13_lv_pmos ad=0.1218p pd=1.13u as=0.2856p ps=1.52u w=0.84u l=0.13u
X44 a_1962_460# a_942_136# a_1964_159# VSS sg13_lv_nmos ad=0.15327p pd=1.255u as=49.5f ps=0.73u w=0.55u l=0.13u
X45 VSS RESET_B a_1715_123# VSS sg13_lv_nmos ad=0.1254p pd=1.12u as=0.1428p ps=1.52u w=0.42u l=0.13u
X46 VDD SCD a_64_504# VDD sg13_lv_pmos ad=0.1216p pd=1.02u as=0.2176p ps=1.96u w=0.64u l=0.13u
X47 a_2148_114# a_698_136# a_1962_460# VSS sg13_lv_nmos ad=79.8f pd=0.8u as=0.15327p ps=1.255u w=0.42u l=0.13u
C0 a_2128_482# VDD 0.73775f
C1 a_942_136# a_1962_460# 0.03554f
C2 Q a_3023_114# 0.08393f
C3 a_260_159# a_1179_136# 0.3958f
C4 a_399_123# a_64_504# 0.01745f
C5 a_2128_482# a_3023_114# 0.11807f
C6 a_2128_482# RESET_B 0.1387f
C7 a_399_123# D 0.07233f
C8 a_2358_114# a_1962_460# 0.0784f
C9 VDD a_64_504# 0.45366f
C10 a_2128_482# a_1715_123# 0.35056f
C11 SET_B a_1339_271# 0.61085f
C12 SET_B a_698_136# 0.05655f
C13 a_399_123# a_698_136# 0.25392f
C14 SCE a_260_159# 0.05382f
C15 SET_B a_942_136# 0.023f
C16 VDD D 0.08171f
C17 VDD a_1339_271# 0.1361f
C18 a_698_136# VDD 0.85153f
C19 SET_B a_1853_419# 0.02004f
C20 a_942_136# VDD 0.30481f
C21 VDD SCD 0.09502f
C22 a_64_504# a_260_504# 0.01583f
C23 a_1339_271# a_1179_136# 0.63511f
C24 a_64_504# a_260_159# 0.11414f
C25 a_698_136# a_1179_136# 0.02916f
C26 SCE a_64_504# 0.08322f
C27 a_1505_165# a_1339_271# 0.27444f
C28 VDD Q_N 0.08664f
C29 a_1715_123# a_1339_271# 0.26973f
C30 a_1715_123# a_698_136# 0.03995f
C31 a_942_136# a_1179_136# 0.03833f
C32 CLK VDD 0.07611f
C33 a_1505_165# a_942_136# 0.01451f
C34 Q_N a_3023_114# 0.4033f
C35 SET_B a_1962_460# 0.67654f
C36 a_1715_123# a_942_136# 0.01303f
C37 a_260_159# D 0.21743f
C38 SCE D 0.11915f
C39 a_698_136# a_260_159# 0.13781f
C40 a_942_136# a_260_159# 0.59548f
C41 VDD a_1962_460# 0.07196f
C42 a_2128_482# a_698_136# 0.04661f
C43 a_260_159# SCD 0.01191f
C44 SCE SCD 0.17237f
C45 a_2358_114# a_1715_123# 0.11492f
C46 a_2128_482# a_942_136# 0.04063f
C47 CLK a_260_159# 0.10597f
C48 a_2128_482# Q_N 0.23912f
C49 a_64_504# D 0.01958f
C50 CLK SCE 0.01792f
C51 a_1715_123# a_1962_460# 0.13876f
C52 a_2128_482# a_2358_114# 0.19028f
C53 SET_B VDD 0.90199f
C54 a_399_123# VDD 0.27405f
C55 a_64_504# SCD 0.08431f
C56 a_698_136# a_1339_271# 0.19323f
C57 a_2128_482# a_1962_460# 0.15736f
C58 SET_B a_1179_136# 0.2565f
C59 a_942_136# a_1339_271# 0.0941f
C60 a_942_136# a_698_136# 0.38774f
C61 SET_B a_1715_123# 0.04897f
C62 VDD a_3023_114# 0.20746f
C63 RESET_B VDD 0.05184f
C64 VDD a_1179_136# 0.20589f
C65 a_1667_419# SET_B 0.01198f
C66 a_399_123# a_260_159# 0.36666f
C67 a_399_123# SCE 0.1192f
C68 CLK a_698_136# 0.36886f
C69 a_2128_482# a_2479_432# 0.01062f
C70 a_1715_123# VDD 0.19705f
C71 CLK a_942_136# 0.02276f
C72 SET_B a_2128_482# 0.41765f
C73 RESET_B a_1715_123# 0.11311f
C74 a_1505_165# a_1179_136# 0.01272f
C75 VDD a_260_159# 0.06961f
C76 SCE VDD 0.17199f
C77 a_1715_123# a_1179_136# 0.13001f
C78 Q VDD 0.16246f
C79 a_698_136# a_1962_460# 0.42865f
C80 a_1505_165# a_1715_123# 0.01006f
C81 Q VSS 0.24116f
C82 Q_N VSS 0.14595f
C83 RESET_B VSS 0.17095f
C84 SET_B VSS 0.40283f
C85 CLK VSS 0.25644f
C86 D VSS 0.18558f
C87 SCE VSS 0.5505f
C88 SCD VSS 0.25788f
C89 VDD VSS 0.56628f
C90 a_2358_114# VSS 0.27429f $ **FLOATING
C91 a_1505_165# VSS 0.21253f $ **FLOATING
C92 a_3023_114# VSS 0.37514f $ **FLOATING
C93 a_1962_460# VSS 0.32227f $ **FLOATING
C94 a_1339_271# VSS 0.51034f $ **FLOATING
C95 a_1715_123# VSS 0.75604f $ **FLOATING
C96 a_2128_482# VSS 0.68202f $ **FLOATING
C97 a_1179_136# VSS 0.24273f $ **FLOATING
C98 a_942_136# VSS 0.75828f $ **FLOATING
C99 a_260_159# VSS 0.73653f $ **FLOATING
C100 a_64_504# VSS 0.02887f $ **FLOATING
C101 a_698_136# VSS 1.18227f $ **FLOATING
C102 a_399_123# VSS 0.19319f $ **FLOATING
.ends
