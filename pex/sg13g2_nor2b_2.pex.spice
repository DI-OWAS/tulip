* NGSPICE file created from sg13g2_nor2b_2_flat.ext - technology: ihp-sg13g2

.subckt sg13g2_nor2b_2_flat A B_N VDD Y VSS
X0 Y A a_252_412# VDD sg13_lv_pmos ad=0.2128p pd=1.5u as=0.2128p ps=1.5u w=1.12u l=0.13u
X1 a_252_412# A Y VDD sg13_lv_pmos ad=0.2128p pd=1.5u as=0.2128p ps=1.5u w=1.12u l=0.13u
X2 VDD a_50_160# a_252_412# VDD sg13_lv_pmos ad=0.3808p pd=2.92u as=0.2128p ps=1.5u w=1.12u l=0.13u
X3 VSS B_N a_50_160# VSS sg13_lv_nmos ad=0.1448p pd=1.13u as=0.2176p ps=1.96u w=0.64u l=0.13u
X4 Y a_50_160# VSS VSS sg13_lv_nmos ad=0.1368p pd=1.1u as=0.1448p ps=1.13u w=0.72u l=0.13u
X5 VSS A Y VSS sg13_lv_nmos ad=0.1368p pd=1.1u as=0.1368p ps=1.1u w=0.72u l=0.13u
X6 Y A VSS VSS sg13_lv_nmos ad=0.1368p pd=1.1u as=0.1368p ps=1.1u w=0.72u l=0.13u
X7 VSS a_50_160# Y VSS sg13_lv_nmos ad=0.2448p pd=2.12u as=0.1368p ps=1.1u w=0.72u l=0.13u
X8 VDD B_N a_50_160# VDD sg13_lv_pmos ad=0.2254p pd=1.53u as=0.34p ps=2.68u w=1u l=0.13u
X9 a_252_412# a_50_160# VDD VDD sg13_lv_pmos ad=0.2128p pd=1.5u as=0.2254p ps=1.53u w=1.12u l=0.13u
C0 a_50_160# a_252_412# 0.01376f
C1 a_50_160# A 0.11522f
C2 Y a_252_412# 0.3f
C3 Y A 0.18109f
C4 VDD a_50_160# 0.34551f
C5 VDD B_N 0.05554f
C6 Y VDD 0.03744f
C7 A a_252_412# 0.07149f
C8 VDD a_252_412# 0.45232f
C9 VDD A 0.12982f
C10 a_50_160# B_N 0.10985f
C11 Y a_50_160# 0.08098f
C12 Y VSS 0.41922f
C13 A VSS 0.48185f
C14 B_N VSS 0.4646f
C15 VDD VSS 0.20154f
C16 a_50_160# VSS 0.83376f $ **FLOATING
.ends
