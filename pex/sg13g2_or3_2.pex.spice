* NGSPICE file created from sg13g2_or3_2_flat.ext - technology: ihp-sg13g2

.subckt sg13g2_or3_2_flat VDD VSS C B A X
X0 VSS A a_73_118# VSS sg13_lv_nmos ad=0.13395p pd=1.12u as=0.198p ps=1.27u w=0.55u l=0.13u
X1 X a_73_118# VSS VSS sg13_lv_nmos ad=0.1443p pd=1.13u as=0.13395p ps=1.12u w=0.74u l=0.13u
X2 VSS a_73_118# X VSS sg13_lv_nmos ad=0.2516p pd=2.16u as=0.1443p ps=1.13u w=0.74u l=0.13u
X3 a_244_412# B a_167_412# VDD sg13_lv_pmos ad=0.22p pd=1.44u as=0.1275p ps=1.255u w=1u l=0.13u
X4 VDD A a_244_412# VDD sg13_lv_pmos ad=0.3822p pd=1.84u as=0.22p ps=1.44u w=1u l=0.13u
X5 VSS C a_73_118# VSS sg13_lv_nmos ad=0.1045p pd=0.93u as=0.187p ps=1.78u w=0.55u l=0.13u
X6 a_167_412# C a_73_118# VDD sg13_lv_pmos ad=0.1275p pd=1.255u as=0.34p ps=2.68u w=1u l=0.13u
X7 a_73_118# B VSS VSS sg13_lv_nmos ad=0.198p pd=1.27u as=0.1045p ps=0.93u w=0.55u l=0.13u
X8 X a_73_118# VDD VDD sg13_lv_pmos ad=0.2128p pd=1.5u as=0.3822p ps=1.84u w=1.12u l=0.13u
X9 VDD a_73_118# X VDD sg13_lv_pmos ad=0.4424p pd=3.03u as=0.2128p ps=1.5u w=1.12u l=0.13u
C0 A a_73_118# 0.27382f
C1 a_73_118# C 0.22361f
C2 A VDD 0.07484f
C3 a_73_118# X 0.27698f
C4 VDD C 0.06384f
C5 VDD a_73_118# 0.38511f
C6 VDD X 0.42457f
C7 a_73_118# a_244_412# 0.02055f
C8 A B 0.13539f
C9 B C 0.11371f
C10 VDD a_244_412# 0.01252f
C11 B a_73_118# 0.22945f
C12 a_167_412# a_73_118# 0.014f
C13 B VDD 0.05356f
C14 X VSS 0.28705f
C15 A VSS 0.22919f
C16 B VSS 0.21748f
C17 C VSS 0.26191f
C18 VDD VSS 0.19471f
C19 a_73_118# VSS 0.86541f $ **FLOATING
.ends
