*================================================================
* GENERIC Testbench Template for Cell Characterization
*===============================================================

.lib '%%MODEL_LIB%%' %%MODEL_CORNER%%
%%PEX_INCLUDES%%
.global vdd vss
*--- Simulation Parameters (ALL SET BY PYTHON) ---
.param VDD_VAL=%%VDD_VAL%%
.param C_LOAD=%%C_LOAD%%
.param CLOCK_SLEW=%%CLOCK_SLEW%%
.param DATA_SLEW=%%DATA_SLEW%%
.param PRELOAD_CLK_TIME=%%PRELOAD_CLK_TIME%%
.param MEASURE_CLK_TIME=%%MEASURE_CLK_TIME%%

*--- Power Supplies ---
VVDD vdd 0 DC {VDD_VAL}
VVSS vss 0 DC 0

*--- Dynamic Initialization Block (Generated by Python) ---
%%INIT_BLOCK%%

*--- Input Stimuli (Generated by Python) ---
%%STIMULI_BLOCK%%

*--- DUT INSTANTIATION ---
Xdut %%PIN_MAPPING%% %%SPICE_MODEL%%

*--- Output Loads ---
CLoad_Q %%OUTPUT_NODE%% VSS {C_LOAD}
%%QN_LOAD_BLOCK%%

*--- Analysis ---
*.options TEMP=%%TEMP_VAL%% TNOM=25 METHOD=TRAP GMIN=1e-15 RELTOL=1e-3
.options TEMP=%%TEMP_VAL%% TNOM=25 METHOD=TRAP GMIN=1e-12 RELTOL=1e-4 ABSTOL=1e-12 VNTOL=1u TRT=1 ITL4=40
.save_currents
.tran 10p 20n uic
.end
